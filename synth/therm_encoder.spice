* Generated by scripts/synthesize.py; do not edit.
.subckt therm_encoder therm_0 therm_1 therm_2 therm_3 therm_4 therm_5 therm_6 therm_7 therm_8 therm_9 therm_10 therm_11 therm_12 therm_13 therm_14 therm_15 code_0 code_1 code_2 code_3 overflow bubble VDD VSS
X_abc_1145_auto_blifparse_cc_386_parse_blif_1146 therm_2 n24 VDD VDD VSS VSS gf180mcu_fd_sc_mcu7t5v0__clkinv_1
X_abc_1145_auto_blifparse_cc_386_parse_blif_1147 therm_3 n25 VDD VDD VSS VSS gf180mcu_fd_sc_mcu7t5v0__clkinv_1
X_abc_1145_auto_blifparse_cc_386_parse_blif_1148 therm_5 n26 VDD VDD VSS VSS gf180mcu_fd_sc_mcu7t5v0__clkinv_1
X_abc_1145_auto_blifparse_cc_386_parse_blif_1149 therm_7 n27 VDD VDD VSS VSS gf180mcu_fd_sc_mcu7t5v0__clkinv_1
X_abc_1145_auto_blifparse_cc_386_parse_blif_1150 therm_9 n28 VDD VDD VSS VSS gf180mcu_fd_sc_mcu7t5v0__clkinv_1
X_abc_1145_auto_blifparse_cc_386_parse_blif_1151 therm_11 n29 VDD VDD VSS VSS gf180mcu_fd_sc_mcu7t5v0__clkinv_1
X_abc_1145_auto_blifparse_cc_386_parse_blif_1152 therm_13 n30 VDD VDD VSS VSS gf180mcu_fd_sc_mcu7t5v0__clkinv_1
X_abc_1145_auto_blifparse_cc_386_parse_blif_1153 therm_14 n31 VDD VDD VSS VSS gf180mcu_fd_sc_mcu7t5v0__clkinv_1
X_abc_1145_auto_blifparse_cc_386_parse_blif_1154 therm_1 therm_0 n32 VDD VDD VSS VSS gf180mcu_fd_sc_mcu7t5v0__nor2_1
X_abc_1145_auto_blifparse_cc_386_parse_blif_1155 therm_2 therm_1 therm_0 n33 VDD VDD VSS VSS gf180mcu_fd_sc_mcu7t5v0__xor3_1
X_abc_1145_auto_blifparse_cc_386_parse_blif_1156 therm_3 n33 n34 VDD VDD VSS VSS gf180mcu_fd_sc_mcu7t5v0__xor2_1
X_abc_1145_auto_blifparse_cc_386_parse_blif_1157 therm_4 n34 n35 VDD VDD VSS VSS gf180mcu_fd_sc_mcu7t5v0__and2_1
X_abc_1145_auto_blifparse_cc_386_parse_blif_1158 therm_4 n34 n36 VDD VDD VSS VSS gf180mcu_fd_sc_mcu7t5v0__nand2_1
X_abc_1145_auto_blifparse_cc_386_parse_blif_1159 therm_4 n34 n37 VDD VDD VSS VSS gf180mcu_fd_sc_mcu7t5v0__nor2_1
X_abc_1145_auto_blifparse_cc_386_parse_blif_1160 therm_3 therm_4 n33 n38 VDD VDD VSS VSS gf180mcu_fd_sc_mcu7t5v0__xor3_1
X_abc_1145_auto_blifparse_cc_386_parse_blif_1161 therm_5 n38 n39 VDD VDD VSS VSS gf180mcu_fd_sc_mcu7t5v0__nand2_1
X_abc_1145_auto_blifparse_cc_386_parse_blif_1162 therm_5 n38 n40 VDD VDD VSS VSS gf180mcu_fd_sc_mcu7t5v0__xor2_1
X_abc_1145_auto_blifparse_cc_386_parse_blif_1163 therm_6 n40 n41 VDD VDD VSS VSS gf180mcu_fd_sc_mcu7t5v0__and2_1
X_abc_1145_auto_blifparse_cc_386_parse_blif_1164 therm_6 n40 n42 VDD VDD VSS VSS gf180mcu_fd_sc_mcu7t5v0__nand2_1
X_abc_1145_auto_blifparse_cc_386_parse_blif_1165 therm_6 n40 n43 VDD VDD VSS VSS gf180mcu_fd_sc_mcu7t5v0__or2_1
X_abc_1145_auto_blifparse_cc_386_parse_blif_1166 therm_5 therm_6 n38 n44 VDD VDD VSS VSS gf180mcu_fd_sc_mcu7t5v0__xor3_1
X_abc_1145_auto_blifparse_cc_386_parse_blif_1167 therm_7 n44 n45 VDD VDD VSS VSS gf180mcu_fd_sc_mcu7t5v0__nand2_1
X_abc_1145_auto_blifparse_cc_386_parse_blif_1168 therm_1 therm_0 therm_2 n46 VDD VDD VSS VSS gf180mcu_fd_sc_mcu7t5v0__aoi21_1
X_abc_1145_auto_blifparse_cc_386_parse_blif_1169 therm_2 therm_1 therm_0 therm_3 n47 VDD VDD VSS VSS gf180mcu_fd_sc_mcu7t5v0__nand4_1
X_abc_1145_auto_blifparse_cc_386_parse_blif_1170 n24 therm_3 n32 n48 VDD VDD VSS VSS gf180mcu_fd_sc_mcu7t5v0__nand3_1
X_abc_1145_auto_blifparse_cc_386_parse_blif_1171 n32 n46 n25 n49 VDD VDD VSS VSS gf180mcu_fd_sc_mcu7t5v0__oai21_1
X_abc_1145_auto_blifparse_cc_386_parse_blif_1172 n47 n48 n49 n50 VDD VDD VSS VSS gf180mcu_fd_sc_mcu7t5v0__nand3_1
X_abc_1145_auto_blifparse_cc_386_parse_blif_1173 n26 n35 n37 n50 n51 VDD VDD VSS VSS gf180mcu_fd_sc_mcu7t5v0__nor4_1
X_abc_1145_auto_blifparse_cc_386_parse_blif_1174 n35 n39 n50 n52 VDD VDD VSS VSS gf180mcu_fd_sc_mcu7t5v0__xor3_1
X_abc_1145_auto_blifparse_cc_386_parse_blif_1175 n41 n52 n53 VDD VDD VSS VSS gf180mcu_fd_sc_mcu7t5v0__and2_1
X_abc_1145_auto_blifparse_cc_386_parse_blif_1176 therm_7 n42 n43 n52 n54 VDD VDD VSS VSS gf180mcu_fd_sc_mcu7t5v0__and4_1
X_abc_1145_auto_blifparse_cc_386_parse_blif_1177 n41 n45 n52 n55 VDD VDD VSS VSS gf180mcu_fd_sc_mcu7t5v0__xor3_1
X_abc_1145_auto_blifparse_cc_386_parse_blif_1178 therm_7 n44 n56 VDD VDD VSS VSS gf180mcu_fd_sc_mcu7t5v0__xor2_1
X_abc_1145_auto_blifparse_cc_386_parse_blif_1179 therm_8 n56 n57 VDD VDD VSS VSS gf180mcu_fd_sc_mcu7t5v0__and2_1
X_abc_1145_auto_blifparse_cc_386_parse_blif_1180 therm_8 n56 n58 VDD VDD VSS VSS gf180mcu_fd_sc_mcu7t5v0__nand2_1
X_abc_1145_auto_blifparse_cc_386_parse_blif_1181 n55 n58 n59 VDD VDD VSS VSS gf180mcu_fd_sc_mcu7t5v0__and2_1
X_abc_1145_auto_blifparse_cc_386_parse_blif_1182 n55 n58 n60 VDD VDD VSS VSS gf180mcu_fd_sc_mcu7t5v0__nor2_1
X_abc_1145_auto_blifparse_cc_386_parse_blif_1183 therm_8 n56 n61 VDD VDD VSS VSS gf180mcu_fd_sc_mcu7t5v0__nor2_1
X_abc_1145_auto_blifparse_cc_386_parse_blif_1184 therm_7 therm_8 n44 n62 VDD VDD VSS VSS gf180mcu_fd_sc_mcu7t5v0__xor3_1
X_abc_1145_auto_blifparse_cc_386_parse_blif_1185 therm_9 n62 n63 VDD VDD VSS VSS gf180mcu_fd_sc_mcu7t5v0__nand2_1
X_abc_1145_auto_blifparse_cc_386_parse_blif_1186 n28 n55 n57 n61 n64 VDD VDD VSS VSS gf180mcu_fd_sc_mcu7t5v0__nor4_1
X_abc_1145_auto_blifparse_cc_386_parse_blif_1187 n55 n58 n63 n65 VDD VDD VSS VSS gf180mcu_fd_sc_mcu7t5v0__xor3_1
X_abc_1145_auto_blifparse_cc_386_parse_blif_1188 therm_9 n62 n66 VDD VDD VSS VSS gf180mcu_fd_sc_mcu7t5v0__xor2_1
X_abc_1145_auto_blifparse_cc_386_parse_blif_1189 therm_10 n66 n67 VDD VDD VSS VSS gf180mcu_fd_sc_mcu7t5v0__and2_1
X_abc_1145_auto_blifparse_cc_386_parse_blif_1190 therm_10 n66 n68 VDD VDD VSS VSS gf180mcu_fd_sc_mcu7t5v0__nand2_1
X_abc_1145_auto_blifparse_cc_386_parse_blif_1191 n65 n68 n69 VDD VDD VSS VSS gf180mcu_fd_sc_mcu7t5v0__nand2_1
X_abc_1145_auto_blifparse_cc_386_parse_blif_1192 n65 n68 n70 VDD VDD VSS VSS gf180mcu_fd_sc_mcu7t5v0__nor2_1
X_abc_1145_auto_blifparse_cc_386_parse_blif_1193 n65 n68 n71 VDD VDD VSS VSS gf180mcu_fd_sc_mcu7t5v0__or2_1
X_abc_1145_auto_blifparse_cc_386_parse_blif_1194 therm_10 n66 n72 VDD VDD VSS VSS gf180mcu_fd_sc_mcu7t5v0__nor2_1
X_abc_1145_auto_blifparse_cc_386_parse_blif_1195 therm_9 therm_10 n62 n73 VDD VDD VSS VSS gf180mcu_fd_sc_mcu7t5v0__xor3_1
X_abc_1145_auto_blifparse_cc_386_parse_blif_1196 therm_11 n73 n74 VDD VDD VSS VSS gf180mcu_fd_sc_mcu7t5v0__and2_1
X_abc_1145_auto_blifparse_cc_386_parse_blif_1197 n29 n65 n67 n72 n75 VDD VDD VSS VSS gf180mcu_fd_sc_mcu7t5v0__nor4_1
X_abc_1145_auto_blifparse_cc_386_parse_blif_1198 n65 n67 n74 n76 VDD VDD VSS VSS gf180mcu_fd_sc_mcu7t5v0__xor3_1
X_abc_1145_auto_blifparse_cc_386_parse_blif_1199 therm_11 n73 n77 VDD VDD VSS VSS gf180mcu_fd_sc_mcu7t5v0__xor2_1
X_abc_1145_auto_blifparse_cc_386_parse_blif_1200 therm_12 n77 n78 VDD VDD VSS VSS gf180mcu_fd_sc_mcu7t5v0__and2_1
X_abc_1145_auto_blifparse_cc_386_parse_blif_1201 therm_12 n77 n79 VDD VDD VSS VSS gf180mcu_fd_sc_mcu7t5v0__nand2_1
X_abc_1145_auto_blifparse_cc_386_parse_blif_1202 n76 n79 n80 VDD VDD VSS VSS gf180mcu_fd_sc_mcu7t5v0__and2_1
X_abc_1145_auto_blifparse_cc_386_parse_blif_1203 n76 n79 n81 VDD VDD VSS VSS gf180mcu_fd_sc_mcu7t5v0__nor2_1
X_abc_1145_auto_blifparse_cc_386_parse_blif_1204 n76 n79 n82 VDD VDD VSS VSS gf180mcu_fd_sc_mcu7t5v0__or2_1
X_abc_1145_auto_blifparse_cc_386_parse_blif_1205 therm_12 n77 n83 VDD VDD VSS VSS gf180mcu_fd_sc_mcu7t5v0__nor2_1
X_abc_1145_auto_blifparse_cc_386_parse_blif_1206 therm_11 therm_12 n73 n84 VDD VDD VSS VSS gf180mcu_fd_sc_mcu7t5v0__xor3_1
X_abc_1145_auto_blifparse_cc_386_parse_blif_1207 therm_13 n84 n85 VDD VDD VSS VSS gf180mcu_fd_sc_mcu7t5v0__nand2_1
X_abc_1145_auto_blifparse_cc_386_parse_blif_1208 n30 n76 n78 n83 n86 VDD VDD VSS VSS gf180mcu_fd_sc_mcu7t5v0__nor4_1
X_abc_1145_auto_blifparse_cc_386_parse_blif_1209 n76 n79 n85 n87 VDD VDD VSS VSS gf180mcu_fd_sc_mcu7t5v0__xor3_1
X_abc_1145_auto_blifparse_cc_386_parse_blif_1210 therm_13 n84 n88 VDD VDD VSS VSS gf180mcu_fd_sc_mcu7t5v0__xor2_1
X_abc_1145_auto_blifparse_cc_386_parse_blif_1211 therm_14 n88 n89 VDD VDD VSS VSS gf180mcu_fd_sc_mcu7t5v0__nand2_1
X_abc_1145_auto_blifparse_cc_386_parse_blif_1212 n87 n89 n90 VDD VDD VSS VSS gf180mcu_fd_sc_mcu7t5v0__nand2_1
X_abc_1145_auto_blifparse_cc_386_parse_blif_1213 n87 n89 n91 VDD VDD VSS VSS gf180mcu_fd_sc_mcu7t5v0__nor2_1
X_abc_1145_auto_blifparse_cc_386_parse_blif_1214 n87 n89 n92 VDD VDD VSS VSS gf180mcu_fd_sc_mcu7t5v0__or2_1
X_abc_1145_auto_blifparse_cc_386_parse_blif_1215 n87 n89 n93 VDD VDD VSS VSS gf180mcu_fd_sc_mcu7t5v0__xor2_1
X_abc_1145_auto_blifparse_cc_386_parse_blif_1216 therm_14 n88 n94 VDD VDD VSS VSS gf180mcu_fd_sc_mcu7t5v0__xor2_1
X_abc_1145_auto_blifparse_cc_386_parse_blif_1217 therm_15 n94 n95 VDD VDD VSS VSS gf180mcu_fd_sc_mcu7t5v0__and2_1
X_abc_1145_auto_blifparse_cc_386_parse_blif_1218 n93 n95 n96 VDD VDD VSS VSS gf180mcu_fd_sc_mcu7t5v0__nand2_1
X_abc_1145_auto_blifparse_cc_386_parse_blif_1219 n93 n95 code_1 VDD VDD VSS VSS gf180mcu_fd_sc_mcu7t5v0__xor2_1
X_abc_1145_auto_blifparse_cc_386_parse_blif_1220 n36 n50 n47 n97 VDD VDD VSS VSS gf180mcu_fd_sc_mcu7t5v0__oai21_1
X_abc_1145_auto_blifparse_cc_386_parse_blif_1221 n41 n52 n97 n51 n98 VDD VDD VSS VSS gf180mcu_fd_sc_mcu7t5v0__aoi211_1
X_abc_1145_auto_blifparse_cc_386_parse_blif_1222 n51 n53 n97 n54 n99 VDD VDD VSS VSS gf180mcu_fd_sc_mcu7t5v0__oai31_1
X_abc_1145_auto_blifparse_cc_386_parse_blif_1223 n54 n98 n100 VDD VDD VSS VSS gf180mcu_fd_sc_mcu7t5v0__xor2_1
X_abc_1145_auto_blifparse_cc_386_parse_blif_1224 n59 n60 n63 n100 n101 VDD VDD VSS VSS gf180mcu_fd_sc_mcu7t5v0__nor4_1
X_abc_1145_auto_blifparse_cc_386_parse_blif_1225 n60 n64 n100 n102 VDD VDD VSS VSS gf180mcu_fd_sc_mcu7t5v0__xnor3_1
X_abc_1145_auto_blifparse_cc_386_parse_blif_1226 n69 n71 n74 n102 n103 VDD VDD VSS VSS gf180mcu_fd_sc_mcu7t5v0__nand4_1
X_abc_1145_auto_blifparse_cc_386_parse_blif_1227 n71 n75 n102 n104 VDD VDD VSS VSS gf180mcu_fd_sc_mcu7t5v0__xor3_1
X_abc_1145_auto_blifparse_cc_386_parse_blif_1228 n80 n81 n85 n104 n105 VDD VDD VSS VSS gf180mcu_fd_sc_mcu7t5v0__nor4_1
X_abc_1145_auto_blifparse_cc_386_parse_blif_1229 n82 n86 n104 n106 VDD VDD VSS VSS gf180mcu_fd_sc_mcu7t5v0__xor3_1
X_abc_1145_auto_blifparse_cc_386_parse_blif_1230 n90 n92 n95 n106 n107 VDD VDD VSS VSS gf180mcu_fd_sc_mcu7t5v0__nand4_1
X_abc_1145_auto_blifparse_cc_386_parse_blif_1231 n92 n96 n106 code_2 VDD VDD VSS VSS gf180mcu_fd_sc_mcu7t5v0__xor3_1
X_abc_1145_auto_blifparse_cc_386_parse_blif_1232 n55 n58 n100 n99 n108 VDD VDD VSS VSS gf180mcu_fd_sc_mcu7t5v0__oai31_1
X_abc_1145_auto_blifparse_cc_386_parse_blif_1233 n70 n102 n108 n101 n109 VDD VDD VSS VSS gf180mcu_fd_sc_mcu7t5v0__aoi211_1
X_abc_1145_auto_blifparse_cc_386_parse_blif_1234 n82 n104 n109 n103 n110 VDD VDD VSS VSS gf180mcu_fd_sc_mcu7t5v0__oai211_1
X_abc_1145_auto_blifparse_cc_386_parse_blif_1235 n91 n106 n110 n105 n111 VDD VDD VSS VSS gf180mcu_fd_sc_mcu7t5v0__aoi211_1
X_abc_1145_auto_blifparse_cc_386_parse_blif_1236 n107 n111 code_3 VDD VDD VSS VSS gf180mcu_fd_sc_mcu7t5v0__xor2_1
X_abc_1145_auto_blifparse_cc_386_parse_blif_1237 therm_12 n31 n30 n112 VDD VDD VSS VSS gf180mcu_fd_sc_mcu7t5v0__mux2_1
X_abc_1145_auto_blifparse_cc_386_parse_blif_1238 therm_8 therm_9 n113 VDD VDD VSS VSS gf180mcu_fd_sc_mcu7t5v0__nand2_1
X_abc_1145_auto_blifparse_cc_386_parse_blif_1239 therm_9 therm_10 n113 n114 VDD VDD VSS VSS gf180mcu_fd_sc_mcu7t5v0__oai21_1
X_abc_1145_auto_blifparse_cc_386_parse_blif_1240 therm_10 therm_11 n115 VDD VDD VSS VSS gf180mcu_fd_sc_mcu7t5v0__nand2_1
X_abc_1145_auto_blifparse_cc_386_parse_blif_1241 therm_11 therm_12 n115 n116 VDD VDD VSS VSS gf180mcu_fd_sc_mcu7t5v0__oai21_1
X_abc_1145_auto_blifparse_cc_386_parse_blif_1242 n24 therm_0 therm_1 n117 VDD VDD VSS VSS gf180mcu_fd_sc_mcu7t5v0__mux2_1
X_abc_1145_auto_blifparse_cc_386_parse_blif_1243 n112 n114 n116 n117 n118 VDD VDD VSS VSS gf180mcu_fd_sc_mcu7t5v0__and4_1
X_abc_1145_auto_blifparse_cc_386_parse_blif_1244 therm_6 n27 n119 VDD VDD VSS VSS gf180mcu_fd_sc_mcu7t5v0__nor2_1
X_abc_1145_auto_blifparse_cc_386_parse_blif_1245 n27 therm_8 n31 therm_15 n119 n120 VDD VDD VSS VSS gf180mcu_fd_sc_mcu7t5v0__aoi221_1
X_abc_1145_auto_blifparse_cc_386_parse_blif_1246 therm_2 n25 therm_4 n26 n121 VDD VDD VSS VSS gf180mcu_fd_sc_mcu7t5v0__oai22_1
X_abc_1145_auto_blifparse_cc_386_parse_blif_1247 n25 therm_4 n26 therm_6 n121 n122 VDD VDD VSS VSS gf180mcu_fd_sc_mcu7t5v0__aoi221_1
X_abc_1145_auto_blifparse_cc_386_parse_blif_1248 n118 n120 n122 bubble VDD VDD VSS VSS gf180mcu_fd_sc_mcu7t5v0__nand3_1
X_abc_1145_auto_blifparse_cc_386_parse_blif_1249 therm_12 therm_13 therm_14 therm_15 n123 VDD VDD VSS VSS gf180mcu_fd_sc_mcu7t5v0__nand4_1
X_abc_1145_auto_blifparse_cc_386_parse_blif_1250 n99 n113 n115 n123 overflow VDD VDD VSS VSS gf180mcu_fd_sc_mcu7t5v0__nor4_1
X_abc_1145_auto_blifparse_cc_386_parse_blif_1251 therm_15 n94 code_0 VDD VDD VSS VSS gf180mcu_fd_sc_mcu7t5v0__xor2_1
.ends therm_encoder
