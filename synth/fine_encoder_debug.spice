* Simulation-only fine encoder, not a physical implementation
* t0 = fd[8]; t8 = fd[0]
* Expected valid pattern: 000...111
.subckt fine_encoder_debug t0 t1 t2 t3 t4 t5 t6 t7 t8 c0 c1 c2 c3 overflow bubble VDD VSS
Bzeros nz VSS v={9-(u(v(t0,VSS)-0.5*v(VDD,VSS))+u(v(t1,VSS)-0.5*v(VDD,VSS))+u(v(t2,VSS)-0.5*v(VDD,VSS))+u(v(t3,VSS)-0.5*v(VDD,VSS))+u(v(t4,VSS)-0.5*v(VDD,VSS))+u(v(t5,VSS)-0.5*v(VDD,VSS))+u(v(t6,VSS)-0.5*v(VDD,VSS))+u(v(t7,VSS)-0.5*v(VDD,VSS))+u(v(t8,VSS)-0.5*v(VDD,VSS)))}
Bcode0 c0 VSS v={v(VDD,VSS)*((u(v(nz,VSS)-0.5)-u(v(nz,VSS)-1.5))+(u(v(nz,VSS)-2.5)-u(v(nz,VSS)-3.5))+(u(v(nz,VSS)-4.5)-u(v(nz,VSS)-5.5))+(u(v(nz,VSS)-6.5)-u(v(nz,VSS)-7.5))+(u(v(nz,VSS)-8.5)-u(v(nz,VSS)-9.5)))}}
Bcode1 c1 VSS v={v(VDD,VSS)*((u(v(nz,VSS)-1.5)-u(v(nz,VSS)-2.5))+(u(v(nz,VSS)-2.5)-u(v(nz,VSS)-3.5))+(u(v(nz,VSS)-5.5)-u(v(nz,VSS)-6.5))+(u(v(nz,VSS)-6.5)-u(v(nz,VSS)-7.5)))}}
Bcode2 c2 VSS v={v(VDD,VSS)*((u(v(nz,VSS)-3.5)-u(v(nz,VSS)-4.5))+(u(v(nz,VSS)-4.5)-u(v(nz,VSS)-5.5))+(u(v(nz,VSS)-5.5)-u(v(nz,VSS)-6.5))+(u(v(nz,VSS)-6.5)-u(v(nz,VSS)-7.5)))}}
Bcode3 c3 VSS v={v(VDD,VSS)*((u(v(nz,VSS)-7.5)-u(v(nz,VSS)-8.5))+(u(v(nz,VSS)-8.5)-u(v(nz,VSS)-9.5)))}}
Bno_catch overflow VSS v={v(VDD,VSS)*u(v(nz,VSS)-8.5)}
Bbubble bubble VSS v={v(VDD,VSS)*u(((u(v(t0,VSS)-0.5*v(VDD,VSS))*(1-u(v(t1,VSS)-0.5*v(VDD,VSS))))+(u(v(t1,VSS)-0.5*v(VDD,VSS))*(1-u(v(t2,VSS)-0.5*v(VDD,VSS))))+(u(v(t2,VSS)-0.5*v(VDD,VSS))*(1-u(v(t3,VSS)-0.5*v(VDD,VSS))))+(u(v(t3,VSS)-0.5*v(VDD,VSS))*(1-u(v(t4,VSS)-0.5*v(VDD,VSS))))+(u(v(t4,VSS)-0.5*v(VDD,VSS))*(1-u(v(t5,VSS)-0.5*v(VDD,VSS))))+(u(v(t5,VSS)-0.5*v(VDD,VSS))*(1-u(v(t6,VSS)-0.5*v(VDD,VSS))))+(u(v(t6,VSS)-0.5*v(VDD,VSS))*(1-u(v(t7,VSS)-0.5*v(VDD,VSS))))+(u(v(t7,VSS)-0.5*v(VDD,VSS))*(1-u(v(t8,VSS)-0.5*v(VDD,VSS)))))-0.5)}
.ends fine_encoder_debug
