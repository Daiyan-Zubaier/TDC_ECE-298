* Generated by scripts/synthesize.py; do not edit.
.subckt counter clk rst_n count_0 count_1 count_2 count_3 VDD VSS
X_abc_162_auto_blifparse_cc_386_parse_blif_163 rst_n n8 VDD VDD VSS VSS gf180mcu_fd_sc_mcu7t5v0__clkinv_1
X_abc_162_auto_blifparse_cc_386_parse_blif_164 count_0 n8 n9 VDD VDD VSS VSS gf180mcu_fd_sc_mcu7t5v0__nor2_1
X_abc_162_auto_blifparse_cc_386_parse_blif_165 count_0 count_1 rst_n n10 VDD VDD VSS VSS gf180mcu_fd_sc_mcu7t5v0__oai21_1
X_abc_162_auto_blifparse_cc_386_parse_blif_166 count_0 count_1 n10 n11 VDD VDD VSS VSS gf180mcu_fd_sc_mcu7t5v0__aoi21_1
X_abc_162_auto_blifparse_cc_386_parse_blif_167 count_0 count_1 count_2 n12 VDD VDD VSS VSS gf180mcu_fd_sc_mcu7t5v0__nand3_1
X_abc_162_auto_blifparse_cc_386_parse_blif_168 count_0 count_1 count_2 n13 VDD VDD VSS VSS gf180mcu_fd_sc_mcu7t5v0__aoi21_1
X_abc_162_auto_blifparse_cc_386_parse_blif_169 n8 n13 n14 VDD VDD VSS VSS gf180mcu_fd_sc_mcu7t5v0__nor2_1
X_abc_162_auto_blifparse_cc_386_parse_blif_170 n12 n14 n15 VDD VDD VSS VSS gf180mcu_fd_sc_mcu7t5v0__and2_1
X_abc_162_auto_blifparse_cc_386_parse_blif_171 count_3 n12 n16 VDD VDD VSS VSS gf180mcu_fd_sc_mcu7t5v0__xor2_1
X_abc_162_auto_blifparse_cc_386_parse_blif_172 n8 n16 n17 VDD VDD VSS VSS gf180mcu_fd_sc_mcu7t5v0__nor2_1
X_auto_ff_cc_266_slice_94 n9 clk count_0 VDD VDD VSS VSS gf180mcu_fd_sc_mcu7t5v0__dffq_1
X_auto_ff_cc_266_slice_95 n11 clk count_1 VDD VDD VSS VSS gf180mcu_fd_sc_mcu7t5v0__dffq_1
X_auto_ff_cc_266_slice_96 n15 clk count_2 VDD VDD VSS VSS gf180mcu_fd_sc_mcu7t5v0__dffq_1
X_auto_ff_cc_266_slice_97 n17 clk count_3 VDD VDD VSS VSS gf180mcu_fd_sc_mcu7t5v0__dffq_1
.ends counter
