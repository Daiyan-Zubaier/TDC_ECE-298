* Generated by scripts/synthesize.py; do not edit.
.subckt tdc_frontend event_in accept_event arm_n clk coarse_0 coarse_1 coarse_2 coarse_3 launched captured coarse_sample_0 coarse_sample_1 coarse_sample_2 coarse_sample_3 medium_taps_0 medium_taps_1 medium_taps_2 medium_taps_3 medium_taps_4 medium_taps_5 medium_taps_6 medium_taps_7 medium_taps_8 medium_taps_9 medium_taps_10 medium_taps_11 medium_taps_12 medium_taps_13 medium_taps_14 medium_taps_15 VDD VSS
Xbanks_0__medium_a launched n32 VDD VDD VSS VSS gf180mcu_fd_sc_mcu7t5v0__dlyc_1
Xbanks_0__medium_b n32 n33 VDD VDD VSS VSS gf180mcu_fd_sc_mcu7t5v0__dlyc_1
Xbanks_0__medium_sample n33 captured medium_taps_0 VDD VDD VSS VSS gf180mcu_fd_sc_mcu7t5v0__dffq_1
Xbanks_10__medium_a n34 n35 VDD VDD VSS VSS gf180mcu_fd_sc_mcu7t5v0__dlyc_1
Xbanks_10__medium_b n35 n36 VDD VDD VSS VSS gf180mcu_fd_sc_mcu7t5v0__dlyc_1
Xbanks_10__medium_sample n36 captured medium_taps_10 VDD VDD VSS VSS gf180mcu_fd_sc_mcu7t5v0__dffq_1
Xbanks_11__medium_a n36 n37 VDD VDD VSS VSS gf180mcu_fd_sc_mcu7t5v0__dlyc_1
Xbanks_11__medium_b n37 n38 VDD VDD VSS VSS gf180mcu_fd_sc_mcu7t5v0__dlyc_1
Xbanks_11__medium_sample n38 captured medium_taps_11 VDD VDD VSS VSS gf180mcu_fd_sc_mcu7t5v0__dffq_1
Xbanks_12__medium_a n38 n39 VDD VDD VSS VSS gf180mcu_fd_sc_mcu7t5v0__dlyc_1
Xbanks_12__medium_b n39 n40 VDD VDD VSS VSS gf180mcu_fd_sc_mcu7t5v0__dlyc_1
Xbanks_12__medium_sample n40 captured medium_taps_12 VDD VDD VSS VSS gf180mcu_fd_sc_mcu7t5v0__dffq_1
Xbanks_13__medium_a n40 n41 VDD VDD VSS VSS gf180mcu_fd_sc_mcu7t5v0__dlyc_1
Xbanks_13__medium_b n41 n42 VDD VDD VSS VSS gf180mcu_fd_sc_mcu7t5v0__dlyc_1
Xbanks_13__medium_sample n42 captured medium_taps_13 VDD VDD VSS VSS gf180mcu_fd_sc_mcu7t5v0__dffq_1
Xbanks_14__medium_a n42 n43 VDD VDD VSS VSS gf180mcu_fd_sc_mcu7t5v0__dlyc_1
Xbanks_14__medium_b n43 n44 VDD VDD VSS VSS gf180mcu_fd_sc_mcu7t5v0__dlyc_1
Xbanks_14__medium_sample n44 captured medium_taps_14 VDD VDD VSS VSS gf180mcu_fd_sc_mcu7t5v0__dffq_1
Xbanks_15__medium_a n44 n45 VDD VDD VSS VSS gf180mcu_fd_sc_mcu7t5v0__dlyc_1
Xbanks_15__medium_b n45 n46 VDD VDD VSS VSS gf180mcu_fd_sc_mcu7t5v0__dlyc_1
Xbanks_15__medium_sample n46 captured medium_taps_15 VDD VDD VSS VSS gf180mcu_fd_sc_mcu7t5v0__dffq_1
Xbanks_1__medium_a n33 n47 VDD VDD VSS VSS gf180mcu_fd_sc_mcu7t5v0__dlyc_1
Xbanks_1__medium_b n47 n48 VDD VDD VSS VSS gf180mcu_fd_sc_mcu7t5v0__dlyc_1
Xbanks_1__medium_sample n48 captured medium_taps_1 VDD VDD VSS VSS gf180mcu_fd_sc_mcu7t5v0__dffq_1
Xbanks_2__medium_a n48 n49 VDD VDD VSS VSS gf180mcu_fd_sc_mcu7t5v0__dlyc_1
Xbanks_2__medium_b n49 n50 VDD VDD VSS VSS gf180mcu_fd_sc_mcu7t5v0__dlyc_1
Xbanks_2__medium_sample n50 captured medium_taps_2 VDD VDD VSS VSS gf180mcu_fd_sc_mcu7t5v0__dffq_1
Xbanks_3__medium_a n50 n51 VDD VDD VSS VSS gf180mcu_fd_sc_mcu7t5v0__dlyc_1
Xbanks_3__medium_b n51 n52 VDD VDD VSS VSS gf180mcu_fd_sc_mcu7t5v0__dlyc_1
Xbanks_3__medium_sample n52 captured medium_taps_3 VDD VDD VSS VSS gf180mcu_fd_sc_mcu7t5v0__dffq_1
Xbanks_4__medium_a n52 n53 VDD VDD VSS VSS gf180mcu_fd_sc_mcu7t5v0__dlyc_1
Xbanks_4__medium_b n53 n54 VDD VDD VSS VSS gf180mcu_fd_sc_mcu7t5v0__dlyc_1
Xbanks_4__medium_sample n54 captured medium_taps_4 VDD VDD VSS VSS gf180mcu_fd_sc_mcu7t5v0__dffq_1
Xbanks_5__medium_a n54 n55 VDD VDD VSS VSS gf180mcu_fd_sc_mcu7t5v0__dlyc_1
Xbanks_5__medium_b n55 n56 VDD VDD VSS VSS gf180mcu_fd_sc_mcu7t5v0__dlyc_1
Xbanks_5__medium_sample n56 captured medium_taps_5 VDD VDD VSS VSS gf180mcu_fd_sc_mcu7t5v0__dffq_1
Xbanks_6__medium_a n56 n57 VDD VDD VSS VSS gf180mcu_fd_sc_mcu7t5v0__dlyc_1
Xbanks_6__medium_b n57 n58 VDD VDD VSS VSS gf180mcu_fd_sc_mcu7t5v0__dlyc_1
Xbanks_6__medium_sample n58 captured medium_taps_6 VDD VDD VSS VSS gf180mcu_fd_sc_mcu7t5v0__dffq_1
Xbanks_7__medium_a n58 n59 VDD VDD VSS VSS gf180mcu_fd_sc_mcu7t5v0__dlyc_1
Xbanks_7__medium_b n59 n60 VDD VDD VSS VSS gf180mcu_fd_sc_mcu7t5v0__dlyc_1
Xbanks_7__medium_sample n60 captured medium_taps_7 VDD VDD VSS VSS gf180mcu_fd_sc_mcu7t5v0__dffq_1
Xbanks_8__medium_a n60 n61 VDD VDD VSS VSS gf180mcu_fd_sc_mcu7t5v0__dlyc_1
Xbanks_8__medium_b n61 n62 VDD VDD VSS VSS gf180mcu_fd_sc_mcu7t5v0__dlyc_1
Xbanks_8__medium_sample n62 captured medium_taps_8 VDD VDD VSS VSS gf180mcu_fd_sc_mcu7t5v0__dffq_1
Xbanks_9__medium_a n62 n63 VDD VDD VSS VSS gf180mcu_fd_sc_mcu7t5v0__dlyc_1
Xbanks_9__medium_b n63 n34 VDD VDD VSS VSS gf180mcu_fd_sc_mcu7t5v0__dlyc_1
Xbanks_9__medium_sample n34 captured medium_taps_9 VDD VDD VSS VSS gf180mcu_fd_sc_mcu7t5v0__dffq_1
Xcapture_ff launched arm_n clk captured VDD VDD VSS VSS gf180mcu_fd_sc_mcu7t5v0__dffrnq_4
Xcoarse_latches_0__sample coarse_0 captured coarse_sample_0 VDD VDD VSS VSS gf180mcu_fd_sc_mcu7t5v0__dffq_1
Xcoarse_latches_1__sample coarse_1 captured coarse_sample_1 VDD VDD VSS VSS gf180mcu_fd_sc_mcu7t5v0__dffq_1
Xcoarse_latches_2__sample coarse_2 captured coarse_sample_2 VDD VDD VSS VSS gf180mcu_fd_sc_mcu7t5v0__dffq_1
Xcoarse_latches_3__sample coarse_3 captured coarse_sample_3 VDD VDD VSS VSS gf180mcu_fd_sc_mcu7t5v0__dffq_1
Xlaunch_ff accept_event arm_n event_in launched VDD VDD VSS VSS gf180mcu_fd_sc_mcu7t5v0__dffrnq_4
.ends tdc_frontend
