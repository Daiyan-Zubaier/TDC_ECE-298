* Generated by scripts/synthesize.py; do not edit.
.subckt fine_encoder therm_0 therm_1 therm_2 therm_3 therm_4 therm_5 therm_6 therm_7 therm_8 code_0 code_1 code_2 code_3 overflow bubble VDD VSS
X_abc_355_auto_blifparse_cc_386_parse_blif_356 therm_3 n17 VDD VDD VSS VSS gf180mcu_fd_sc_mcu7t5v0__clkinv_1
X_abc_355_auto_blifparse_cc_386_parse_blif_357 therm_2 n18 VDD VDD VSS VSS gf180mcu_fd_sc_mcu7t5v0__clkinv_1
X_abc_355_auto_blifparse_cc_386_parse_blif_358 therm_5 n19 VDD VDD VSS VSS gf180mcu_fd_sc_mcu7t5v0__clkinv_1
X_abc_355_auto_blifparse_cc_386_parse_blif_359 therm_6 n20 VDD VDD VSS VSS gf180mcu_fd_sc_mcu7t5v0__clkinv_1
X_abc_355_auto_blifparse_cc_386_parse_blif_360 therm_7 therm_6 n21 VDD VDD VSS VSS gf180mcu_fd_sc_mcu7t5v0__nor2_1
X_abc_355_auto_blifparse_cc_386_parse_blif_361 therm_5 therm_4 n22 VDD VDD VSS VSS gf180mcu_fd_sc_mcu7t5v0__nor2_1
X_abc_355_auto_blifparse_cc_386_parse_blif_362 therm_1 therm_0 n23 VDD VDD VSS VSS gf180mcu_fd_sc_mcu7t5v0__nor2_1
X_abc_355_auto_blifparse_cc_386_parse_blif_363 therm_3 therm_2 n24 VDD VDD VSS VSS gf180mcu_fd_sc_mcu7t5v0__nor2_1
X_abc_355_auto_blifparse_cc_386_parse_blif_364 n22 n23 n24 n25 VDD VDD VSS VSS gf180mcu_fd_sc_mcu7t5v0__nand3_1
X_abc_355_auto_blifparse_cc_386_parse_blif_365 therm_8 therm_7 therm_6 n25 overflow VDD VDD VSS VSS gf180mcu_fd_sc_mcu7t5v0__nor4_1
X_abc_355_auto_blifparse_cc_386_parse_blif_366 therm_1 therm_2 n23 n26 VDD VDD VSS VSS gf180mcu_fd_sc_mcu7t5v0__aoi21_1
X_abc_355_auto_blifparse_cc_386_parse_blif_367 therm_3 therm_4 n24 n27 VDD VDD VSS VSS gf180mcu_fd_sc_mcu7t5v0__aoi21_1
X_abc_355_auto_blifparse_cc_386_parse_blif_368 therm_8 therm_7 n21 n28 VDD VDD VSS VSS gf180mcu_fd_sc_mcu7t5v0__aoi21_1
X_abc_355_auto_blifparse_cc_386_parse_blif_369 therm_5 therm_6 n22 n29 VDD VDD VSS VSS gf180mcu_fd_sc_mcu7t5v0__aoi21_1
X_abc_355_auto_blifparse_cc_386_parse_blif_370 n26 n27 n28 n29 bubble VDD VDD VSS VSS gf180mcu_fd_sc_mcu7t5v0__or4_1
X_abc_355_auto_blifparse_cc_386_parse_blif_371 therm_1 therm_0 n30 VDD VDD VSS VSS gf180mcu_fd_sc_mcu7t5v0__nand2_1
X_abc_355_auto_blifparse_cc_386_parse_blif_372 therm_1 therm_0 therm_3 n31 VDD VDD VSS VSS gf180mcu_fd_sc_mcu7t5v0__xor3_1
X_abc_355_auto_blifparse_cc_386_parse_blif_373 therm_8 n31 n32 VDD VDD VSS VSS gf180mcu_fd_sc_mcu7t5v0__nand2_1
X_abc_355_auto_blifparse_cc_386_parse_blif_374 therm_8 n31 n33 VDD VDD VSS VSS gf180mcu_fd_sc_mcu7t5v0__nor2_1
X_abc_355_auto_blifparse_cc_386_parse_blif_375 therm_8 n19 n31 n34 VDD VDD VSS VSS gf180mcu_fd_sc_mcu7t5v0__xor3_1
X_abc_355_auto_blifparse_cc_386_parse_blif_376 n20 n34 n35 VDD VDD VSS VSS gf180mcu_fd_sc_mcu7t5v0__nand2_1
X_abc_355_auto_blifparse_cc_386_parse_blif_377 n20 n34 n36 VDD VDD VSS VSS gf180mcu_fd_sc_mcu7t5v0__nor2_1
X_abc_355_auto_blifparse_cc_386_parse_blif_378 therm_7 n20 n34 n37 VDD VDD VSS VSS gf180mcu_fd_sc_mcu7t5v0__xor3_1
X_abc_355_auto_blifparse_cc_386_parse_blif_379 therm_4 n37 n38 VDD VDD VSS VSS gf180mcu_fd_sc_mcu7t5v0__nor2_1
X_abc_355_auto_blifparse_cc_386_parse_blif_380 therm_4 n37 n39 VDD VDD VSS VSS gf180mcu_fd_sc_mcu7t5v0__nand2_1
X_abc_355_auto_blifparse_cc_386_parse_blif_381 n18 therm_4 n37 code_0 VDD VDD VSS VSS gf180mcu_fd_sc_mcu7t5v0__xor3_1
X_abc_355_auto_blifparse_cc_386_parse_blif_382 n18 n39 n38 n40 VDD VDD VSS VSS gf180mcu_fd_sc_mcu7t5v0__aoi21_1
X_abc_355_auto_blifparse_cc_386_parse_blif_383 therm_7 n36 n35 n41 VDD VDD VSS VSS gf180mcu_fd_sc_mcu7t5v0__oai21_1
X_abc_355_auto_blifparse_cc_386_parse_blif_384 n19 n32 n33 n42 VDD VDD VSS VSS gf180mcu_fd_sc_mcu7t5v0__aoi21_1
X_abc_355_auto_blifparse_cc_386_parse_blif_385 n17 n30 n23 n43 VDD VDD VSS VSS gf180mcu_fd_sc_mcu7t5v0__aoi21_1
X_abc_355_auto_blifparse_cc_386_parse_blif_386 n42 n43 n44 VDD VDD VSS VSS gf180mcu_fd_sc_mcu7t5v0__nor2_1
X_abc_355_auto_blifparse_cc_386_parse_blif_387 n42 n43 n45 VDD VDD VSS VSS gf180mcu_fd_sc_mcu7t5v0__xor2_1
X_abc_355_auto_blifparse_cc_386_parse_blif_388 n41 n45 n46 VDD VDD VSS VSS gf180mcu_fd_sc_mcu7t5v0__nand2_1
X_abc_355_auto_blifparse_cc_386_parse_blif_389 n41 n45 n47 VDD VDD VSS VSS gf180mcu_fd_sc_mcu7t5v0__nor2_1
X_abc_355_auto_blifparse_cc_386_parse_blif_390 n40 n41 n45 code_1 VDD VDD VSS VSS gf180mcu_fd_sc_mcu7t5v0__xnor3_1
X_abc_355_auto_blifparse_cc_386_parse_blif_391 n40 n47 n46 n48 VDD VDD VSS VSS gf180mcu_fd_sc_mcu7t5v0__oai21_1
X_abc_355_auto_blifparse_cc_386_parse_blif_392 n44 n48 code_3 VDD VDD VSS VSS gf180mcu_fd_sc_mcu7t5v0__and2_1
X_abc_355_auto_blifparse_cc_386_parse_blif_393 n44 n48 code_2 VDD VDD VSS VSS gf180mcu_fd_sc_mcu7t5v0__xor2_1
.ends fine_encoder
