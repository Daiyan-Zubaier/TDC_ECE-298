* Generated by scripts/synthesize.py; do not edit.
.subckt tt_um_daiyan_tdc ui_in_0 ui_in_1 ui_in_2 ui_in_3 ui_in_4 ui_in_5 ui_in_6 ui_in_7 uo_out_0 uo_out_1 uo_out_2 uo_out_3 uo_out_4 uo_out_5 uo_out_6 uo_out_7 uio_in_0 uio_in_1 uio_in_2 uio_in_3 uio_in_4 uio_in_5 uio_in_6 uio_in_7 uio_out_0 uio_out_1 uio_out_2 uio_out_3 uio_out_4 uio_out_5 uio_out_6 uio_out_7 uio_oe_0 uio_oe_1 uio_oe_2 uio_oe_3 uio_oe_4 uio_oe_5 uio_oe_6 uio_oe_7 ua_0 ua_1 ua_2 ua_3 ua_4 ua_5 ua_6 ua_7 ena clk rst_n VDD VSS
Vwire_uio_out_3 uio_out_3 VSS 0
Vwire_uio_out_4 uio_out_4 VSS 0
Vwire_uio_out_5 uio_out_5 VSS 0
Vwire_uio_out_6 uio_out_6 VSS 0
Vwire_uio_out_7 uio_out_7 VSS 0
Vwire_uio_oe_1 uio_oe_1 uio_oe_0 0
Vwire_uio_oe_2 uio_oe_2 uio_oe_0 0
Vwire_uio_oe_3 uio_oe_3 VSS 0
Vwire_uio_oe_4 uio_oe_4 VSS 0
Vwire_uio_oe_5 uio_oe_5 VSS 0
Vwire_uio_oe_6 uio_oe_6 VSS 0
Vwire_uio_oe_7 uio_oe_7 VSS 0
Vwire_ena ena uio_oe_0 0
X_abc_2207_auto_blifparse_cc_386_parse_blif_2208 uio_oe_0 n40 VDD VDD VSS VSS gf180mcu_fd_sc_mcu7t5v0__clkinv_1
X_abc_2207_auto_blifparse_cc_386_parse_blif_2209 n41 n42 VDD VDD VSS VSS gf180mcu_fd_sc_mcu7t5v0__clkinv_1
X_abc_2207_auto_blifparse_cc_386_parse_blif_2210 n43 n44 VDD VDD VSS VSS gf180mcu_fd_sc_mcu7t5v0__clkinv_1
X_abc_2207_auto_blifparse_cc_386_parse_blif_2211 n45 n46 VDD VDD VSS VSS gf180mcu_fd_sc_mcu7t5v0__clkinv_1
X_abc_2207_auto_blifparse_cc_386_parse_blif_2212 n47 n48 VDD VDD VSS VSS gf180mcu_fd_sc_mcu7t5v0__clkinv_1
X_abc_2207_auto_blifparse_cc_386_parse_blif_2213 n49 n50 VDD VDD VSS VSS gf180mcu_fd_sc_mcu7t5v0__clkinv_1
X_abc_2207_auto_blifparse_cc_386_parse_blif_2214 n51 n52 VDD VDD VSS VSS gf180mcu_fd_sc_mcu7t5v0__clkinv_1
X_abc_2207_auto_blifparse_cc_386_parse_blif_2215 n53 n54 VDD VDD VSS VSS gf180mcu_fd_sc_mcu7t5v0__clkinv_1
X_abc_2207_auto_blifparse_cc_386_parse_blif_2216 n55 n56 VDD VDD VSS VSS gf180mcu_fd_sc_mcu7t5v0__clkinv_1
X_abc_2207_auto_blifparse_cc_386_parse_blif_2217 n57 n58 VDD VDD VSS VSS gf180mcu_fd_sc_mcu7t5v0__clkinv_1
X_abc_2207_auto_blifparse_cc_386_parse_blif_2218 n59 n60 VDD VDD VSS VSS gf180mcu_fd_sc_mcu7t5v0__clkinv_1
X_abc_2207_auto_blifparse_cc_386_parse_blif_2219 n61 n62 VDD VDD VSS VSS gf180mcu_fd_sc_mcu7t5v0__clkinv_1
X_abc_2207_auto_blifparse_cc_386_parse_blif_2220 n63 n64 VDD VDD VSS VSS gf180mcu_fd_sc_mcu7t5v0__clkinv_1
X_abc_2207_auto_blifparse_cc_386_parse_blif_2221 n65 n66 VDD VDD VSS VSS gf180mcu_fd_sc_mcu7t5v0__clkinv_1
X_abc_2207_auto_blifparse_cc_386_parse_blif_2222 ui_in_0 n67 VDD VDD VSS VSS gf180mcu_fd_sc_mcu7t5v0__clkinv_1
X_abc_2207_auto_blifparse_cc_386_parse_blif_2223 n68 n69 VDD VDD VSS VSS gf180mcu_fd_sc_mcu7t5v0__clkinv_1
X_abc_2207_auto_blifparse_cc_386_parse_blif_2224 n70 n71 VDD VDD VSS VSS gf180mcu_fd_sc_mcu7t5v0__clkinv_1
X_abc_2207_auto_blifparse_cc_386_parse_blif_2225 n72 n73 VDD VDD VSS VSS gf180mcu_fd_sc_mcu7t5v0__clkinv_1
X_abc_2207_auto_blifparse_cc_386_parse_blif_2226 n74 n75 VDD VDD VSS VSS gf180mcu_fd_sc_mcu7t5v0__clkinv_1
X_abc_2207_auto_blifparse_cc_386_parse_blif_2227 n76 n77 VDD VDD VSS VSS gf180mcu_fd_sc_mcu7t5v0__clkinv_1
X_abc_2207_auto_blifparse_cc_386_parse_blif_2228 n78 n79 VDD VDD VSS VSS gf180mcu_fd_sc_mcu7t5v0__clkinv_1
X_abc_2207_auto_blifparse_cc_386_parse_blif_2229 n80 n81 VDD VDD VSS VSS gf180mcu_fd_sc_mcu7t5v0__clkinv_1
X_abc_2207_auto_blifparse_cc_386_parse_blif_2230 n82 n83 VDD VDD VSS VSS gf180mcu_fd_sc_mcu7t5v0__clkinv_1
X_abc_2207_auto_blifparse_cc_386_parse_blif_2231 n84 n85 VDD VDD VSS VSS gf180mcu_fd_sc_mcu7t5v0__clkinv_1
X_abc_2207_auto_blifparse_cc_386_parse_blif_2232 n86 n87 VDD VDD VSS VSS gf180mcu_fd_sc_mcu7t5v0__clkinv_1
X_abc_2207_auto_blifparse_cc_386_parse_blif_2233 n88 n89 VDD VDD VSS VSS gf180mcu_fd_sc_mcu7t5v0__clkinv_1
X_abc_2207_auto_blifparse_cc_386_parse_blif_2234 n90 n91 VDD VDD VSS VSS gf180mcu_fd_sc_mcu7t5v0__clkinv_1
X_abc_2207_auto_blifparse_cc_386_parse_blif_2235 n92 n93 VDD VDD VSS VSS gf180mcu_fd_sc_mcu7t5v0__clkinv_1
X_abc_2207_auto_blifparse_cc_386_parse_blif_2236 n94 n41 n95 VDD VDD VSS VSS gf180mcu_fd_sc_mcu7t5v0__nand2_1
X_abc_2207_auto_blifparse_cc_386_parse_blif_2237 n94 n41 n43 n96 n97 VDD VDD VSS VSS gf180mcu_fd_sc_mcu7t5v0__and4_1
X_abc_2207_auto_blifparse_cc_386_parse_blif_2238 n40 n97 n98 VDD VDD VSS VSS gf180mcu_fd_sc_mcu7t5v0__nor2_1
X_abc_2207_auto_blifparse_cc_386_parse_blif_2239 n99 n98 n100 VDD VDD VSS VSS gf180mcu_fd_sc_mcu7t5v0__nand2_1
X_abc_2207_auto_blifparse_cc_386_parse_blif_2240 n101 n102 n103 VDD VDD VSS VSS gf180mcu_fd_sc_mcu7t5v0__nand2_1
X_abc_2207_auto_blifparse_cc_386_parse_blif_2241 n101 n102 n104 n45 n105 VDD VDD VSS VSS gf180mcu_fd_sc_mcu7t5v0__and4_1
X_abc_2207_auto_blifparse_cc_386_parse_blif_2242 uio_oe_0 n106 n107 VDD VDD VSS VSS gf180mcu_fd_sc_mcu7t5v0__and2_1
X_abc_2207_auto_blifparse_cc_386_parse_blif_2243 uio_oe_0 n106 n108 VDD VDD VSS VSS gf180mcu_fd_sc_mcu7t5v0__nand2_1
X_abc_2207_auto_blifparse_cc_386_parse_blif_2244 n105 n108 n109 VDD VDD VSS VSS gf180mcu_fd_sc_mcu7t5v0__or2_1
X_abc_2207_auto_blifparse_cc_386_parse_blif_2245 n109 n110 VDD VDD VSS VSS gf180mcu_fd_sc_mcu7t5v0__clkinv_1
X_abc_2207_auto_blifparse_cc_386_parse_blif_2246 n48 n109 n100 n111 VDD VDD VSS VSS gf180mcu_fd_sc_mcu7t5v0__oai21_1
X_abc_2207_auto_blifparse_cc_386_parse_blif_2247 n112 n113 n114 VDD VDD VSS VSS gf180mcu_fd_sc_mcu7t5v0__xnor2_1
X_abc_2207_auto_blifparse_cc_386_parse_blif_2248 n115 n114 n116 VDD VDD VSS VSS gf180mcu_fd_sc_mcu7t5v0__nor2_1
X_abc_2207_auto_blifparse_cc_386_parse_blif_2249 uio_oe_0 n117 n118 VDD VDD VSS VSS gf180mcu_fd_sc_mcu7t5v0__nand2_1
X_abc_2207_auto_blifparse_cc_386_parse_blif_2250 n119 n118 n120 VDD VDD VSS VSS gf180mcu_fd_sc_mcu7t5v0__nor2_1
X_abc_2207_auto_blifparse_cc_386_parse_blif_2251 n105 n107 n121 VDD VDD VSS VSS gf180mcu_fd_sc_mcu7t5v0__nand2_1
X_abc_2207_auto_blifparse_cc_386_parse_blif_2252 n116 n120 n40 n122 VDD VDD VSS VSS gf180mcu_fd_sc_mcu7t5v0__aoi21_1
X_abc_2207_auto_blifparse_cc_386_parse_blif_2253 n123 n98 n124 VDD VDD VSS VSS gf180mcu_fd_sc_mcu7t5v0__nand2_1
X_abc_2207_auto_blifparse_cc_386_parse_blif_2254 uio_oe_0 n99 n97 n125 VDD VDD VSS VSS gf180mcu_fd_sc_mcu7t5v0__nand3_1
X_abc_2207_auto_blifparse_cc_386_parse_blif_2255 n121 n122 n124 n125 n126 VDD VDD VSS VSS gf180mcu_fd_sc_mcu7t5v0__nand4_1
X_abc_2207_auto_blifparse_cc_386_parse_blif_2256 n115 n114 n120 n127 VDD VDD VSS VSS gf180mcu_fd_sc_mcu7t5v0__oai21_1
X_abc_2207_auto_blifparse_cc_386_parse_blif_2257 uio_oe_0 n123 n97 n128 VDD VDD VSS VSS gf180mcu_fd_sc_mcu7t5v0__nand3_1
X_abc_2207_auto_blifparse_cc_386_parse_blif_2258 n127 n128 n129 VDD VDD VSS VSS gf180mcu_fd_sc_mcu7t5v0__nand2_1
X_abc_2207_auto_blifparse_cc_386_parse_blif_2259 uio_oe_0 n119 n117 n130 VDD VDD VSS VSS gf180mcu_fd_sc_mcu7t5v0__nand3_1
X_abc_2207_auto_blifparse_cc_386_parse_blif_2260 n47 n109 n130 n131 VDD VDD VSS VSS gf180mcu_fd_sc_mcu7t5v0__oai21_1
X_abc_2207_auto_blifparse_cc_386_parse_blif_2261 uio_oe_0 n132 n133 n134 VDD VDD VSS VSS gf180mcu_fd_sc_mcu7t5v0__and3_1
X_abc_2207_auto_blifparse_cc_386_parse_blif_2262 n113 n68 n135 VDD VDD VSS VSS gf180mcu_fd_sc_mcu7t5v0__and2_1
X_abc_2207_auto_blifparse_cc_386_parse_blif_2263 n113 n69 n136 VDD VDD VSS VSS gf180mcu_fd_sc_mcu7t5v0__nor2_1
X_abc_2207_auto_blifparse_cc_386_parse_blif_2264 n40 n123 n137 VDD VDD VSS VSS gf180mcu_fd_sc_mcu7t5v0__nor2_1
X_abc_2207_auto_blifparse_cc_386_parse_blif_2265 n40 n123 n138 VDD VDD VSS VSS gf180mcu_fd_sc_mcu7t5v0__or2_1
X_abc_2207_auto_blifparse_cc_386_parse_blif_2266 n115 n137 n139 VDD VDD VSS VSS gf180mcu_fd_sc_mcu7t5v0__and2_1
X_abc_2207_auto_blifparse_cc_386_parse_blif_2267 n140 n137 n141 VDD VDD VSS VSS gf180mcu_fd_sc_mcu7t5v0__and2_1
X_abc_2207_auto_blifparse_cc_386_parse_blif_2268 n142 n143 n113 n144 VDD VDD VSS VSS gf180mcu_fd_sc_mcu7t5v0__mux2_1
X_abc_2207_auto_blifparse_cc_386_parse_blif_2269 n137 n144 n145 VDD VDD VSS VSS gf180mcu_fd_sc_mcu7t5v0__and2_1
X_abc_2207_auto_blifparse_cc_386_parse_blif_2270 n146 n137 n147 VDD VDD VSS VSS gf180mcu_fd_sc_mcu7t5v0__and2_1
X_abc_2207_auto_blifparse_cc_386_parse_blif_2271 n40 n79 uo_out_0 VDD VDD VSS VSS gf180mcu_fd_sc_mcu7t5v0__nor2_1
X_abc_2207_auto_blifparse_cc_386_parse_blif_2272 n40 n81 uo_out_1 VDD VDD VSS VSS gf180mcu_fd_sc_mcu7t5v0__nor2_1
X_abc_2207_auto_blifparse_cc_386_parse_blif_2273 n40 n83 uo_out_2 VDD VDD VSS VSS gf180mcu_fd_sc_mcu7t5v0__nor2_1
X_abc_2207_auto_blifparse_cc_386_parse_blif_2274 n40 n85 uo_out_3 VDD VDD VSS VSS gf180mcu_fd_sc_mcu7t5v0__nor2_1
X_abc_2207_auto_blifparse_cc_386_parse_blif_2275 n40 n87 uo_out_4 VDD VDD VSS VSS gf180mcu_fd_sc_mcu7t5v0__nor2_1
X_abc_2207_auto_blifparse_cc_386_parse_blif_2276 n40 n89 uo_out_5 VDD VDD VSS VSS gf180mcu_fd_sc_mcu7t5v0__nor2_1
X_abc_2207_auto_blifparse_cc_386_parse_blif_2277 n40 n91 uo_out_6 VDD VDD VSS VSS gf180mcu_fd_sc_mcu7t5v0__nor2_1
X_abc_2207_auto_blifparse_cc_386_parse_blif_2278 n40 n93 uo_out_7 VDD VDD VSS VSS gf180mcu_fd_sc_mcu7t5v0__nor2_1
X_abc_2207_auto_blifparse_cc_386_parse_blif_2279 uio_oe_0 n148 n149 VDD VDD VSS VSS gf180mcu_fd_sc_mcu7t5v0__nand2_1
X_abc_2207_auto_blifparse_cc_386_parse_blif_2280 n115 n149 uio_out_0 VDD VDD VSS VSS gf180mcu_fd_sc_mcu7t5v0__nor2_1
X_abc_2207_auto_blifparse_cc_386_parse_blif_2281 n115 n150 uio_oe_0 n151 VDD VDD VSS VSS gf180mcu_fd_sc_mcu7t5v0__oai21_1
X_abc_2207_auto_blifparse_cc_386_parse_blif_2282 n151 uio_out_1 VDD VDD VSS VSS gf180mcu_fd_sc_mcu7t5v0__clkinv_1
X_abc_2207_auto_blifparse_cc_386_parse_blif_2283 uio_oe_0 n152 uio_out_2 VDD VDD VSS VSS gf180mcu_fd_sc_mcu7t5v0__and2_1
X_abc_2207_auto_blifparse_cc_386_parse_blif_2284 n123 n99 n153 VDD VDD VSS VSS gf180mcu_fd_sc_mcu7t5v0__or2_1
X_abc_2207_auto_blifparse_cc_386_parse_blif_2285 n98 n153 n154 VDD VDD VSS VSS gf180mcu_fd_sc_mcu7t5v0__nand2_1
X_abc_2207_auto_blifparse_cc_386_parse_blif_2286 n109 n154 n155 VDD VDD VSS VSS gf180mcu_fd_sc_mcu7t5v0__and2_1
X_abc_2207_auto_blifparse_cc_386_parse_blif_2287 n106 n99 n138 n155 n156 VDD VDD VSS VSS gf180mcu_fd_sc_mcu7t5v0__oai31_1
X_abc_2207_auto_blifparse_cc_386_parse_blif_2288 n157 n156 n158 VDD VDD VSS VSS gf180mcu_fd_sc_mcu7t5v0__nand2_1
X_abc_2207_auto_blifparse_cc_386_parse_blif_2289 n106 n99 n155 uio_oe_0 n159 VDD VDD VSS VSS gf180mcu_fd_sc_mcu7t5v0__oai211_1
X_abc_2207_auto_blifparse_cc_386_parse_blif_2290 n158 n159 n160 VDD VDD VSS VSS gf180mcu_fd_sc_mcu7t5v0__nand2_1
X_abc_2207_auto_blifparse_cc_386_parse_blif_2291 n40 n117 n161 VDD VDD VSS VSS gf180mcu_fd_sc_mcu7t5v0__or2_1
X_abc_2207_auto_blifparse_cc_386_parse_blif_2292 n106 n153 n161 n162 VDD VDD VSS VSS gf180mcu_fd_sc_mcu7t5v0__nor3_1
X_abc_2207_auto_blifparse_cc_386_parse_blif_2293 n127 n130 n163 VDD VDD VSS VSS gf180mcu_fd_sc_mcu7t5v0__nand2_1
X_abc_2207_auto_blifparse_cc_386_parse_blif_2294 n162 n163 n164 VDD VDD VSS VSS gf180mcu_fd_sc_mcu7t5v0__nor2_1
X_abc_2207_auto_blifparse_cc_386_parse_blif_2295 n48 n110 n162 n163 n165 VDD VDD VSS VSS gf180mcu_fd_sc_mcu7t5v0__aoi211_1
X_abc_2207_auto_blifparse_cc_386_parse_blif_2296 n41 n165 n166 VDD VDD VSS VSS gf180mcu_fd_sc_mcu7t5v0__and2_1
X_abc_2207_auto_blifparse_cc_386_parse_blif_2297 uio_oe_0 n153 n165 n167 VDD VDD VSS VSS gf180mcu_fd_sc_mcu7t5v0__nand3_1
X_abc_2207_auto_blifparse_cc_386_parse_blif_2298 n42 n167 n166 n168 VDD VDD VSS VSS gf180mcu_fd_sc_mcu7t5v0__aoi21_1
X_abc_2207_auto_blifparse_cc_386_parse_blif_2299 n41 n165 n94 n169 VDD VDD VSS VSS gf180mcu_fd_sc_mcu7t5v0__aoi21_1
X_abc_2207_auto_blifparse_cc_386_parse_blif_2300 uio_oe_0 n95 n153 n170 VDD VDD VSS VSS gf180mcu_fd_sc_mcu7t5v0__nand3_1
X_abc_2207_auto_blifparse_cc_386_parse_blif_2301 n165 n170 n171 VDD VDD VSS VSS gf180mcu_fd_sc_mcu7t5v0__nand2_1
X_abc_2207_auto_blifparse_cc_386_parse_blif_2302 n165 n170 n169 n172 VDD VDD VSS VSS gf180mcu_fd_sc_mcu7t5v0__aoi21_1
X_abc_2207_auto_blifparse_cc_386_parse_blif_2303 n96 n171 n173 VDD VDD VSS VSS gf180mcu_fd_sc_mcu7t5v0__nand2_1
X_abc_2207_auto_blifparse_cc_386_parse_blif_2304 n96 n95 n167 n173 n174 VDD VDD VSS VSS gf180mcu_fd_sc_mcu7t5v0__oai31_1
X_abc_2207_auto_blifparse_cc_386_parse_blif_2305 n94 n41 n96 n165 n175 VDD VDD VSS VSS gf180mcu_fd_sc_mcu7t5v0__nand4_1
X_abc_2207_auto_blifparse_cc_386_parse_blif_2306 n154 n165 n175 n44 n176 VDD VDD VSS VSS gf180mcu_fd_sc_mcu7t5v0__aoi22_1
X_abc_2207_auto_blifparse_cc_386_parse_blif_2307 n119 n118 n161 n106 n121 n177 VDD VDD VSS VSS gf180mcu_fd_sc_mcu7t5v0__oai221_1
X_abc_2207_auto_blifparse_cc_386_parse_blif_2308 n47 n110 n177 n178 VDD VDD VSS VSS gf180mcu_fd_sc_mcu7t5v0__aoi21_1
X_abc_2207_auto_blifparse_cc_386_parse_blif_2309 n107 n178 n179 VDD VDD VSS VSS gf180mcu_fd_sc_mcu7t5v0__nand2_1
X_abc_2207_auto_blifparse_cc_386_parse_blif_2310 n107 n178 n102 n180 VDD VDD VSS VSS gf180mcu_fd_sc_mcu7t5v0__aoi21_1
X_abc_2207_auto_blifparse_cc_386_parse_blif_2311 n102 n178 n180 n181 VDD VDD VSS VSS gf180mcu_fd_sc_mcu7t5v0__aoi21_1
X_abc_2207_auto_blifparse_cc_386_parse_blif_2312 n102 n178 n101 n182 VDD VDD VSS VSS gf180mcu_fd_sc_mcu7t5v0__aoi21_1
X_abc_2207_auto_blifparse_cc_386_parse_blif_2313 n103 n107 n183 VDD VDD VSS VSS gf180mcu_fd_sc_mcu7t5v0__nand2_1
X_abc_2207_auto_blifparse_cc_386_parse_blif_2314 n178 n183 n184 VDD VDD VSS VSS gf180mcu_fd_sc_mcu7t5v0__nand2_1
X_abc_2207_auto_blifparse_cc_386_parse_blif_2315 n178 n183 n182 n185 VDD VDD VSS VSS gf180mcu_fd_sc_mcu7t5v0__aoi21_1
X_abc_2207_auto_blifparse_cc_386_parse_blif_2316 n104 n184 n186 VDD VDD VSS VSS gf180mcu_fd_sc_mcu7t5v0__nand2_1
X_abc_2207_auto_blifparse_cc_386_parse_blif_2317 n104 n103 n179 n186 n187 VDD VDD VSS VSS gf180mcu_fd_sc_mcu7t5v0__oai31_1
X_abc_2207_auto_blifparse_cc_386_parse_blif_2318 n101 n102 n104 n178 n188 VDD VDD VSS VSS gf180mcu_fd_sc_mcu7t5v0__nand4_1
X_abc_2207_auto_blifparse_cc_386_parse_blif_2319 n109 n178 n188 n46 n189 VDD VDD VSS VSS gf180mcu_fd_sc_mcu7t5v0__aoi22_1
X_abc_2207_auto_blifparse_cc_386_parse_blif_2320 n106 n99 n161 n190 VDD VDD VSS VSS gf180mcu_fd_sc_mcu7t5v0__nor3_1
X_abc_2207_auto_blifparse_cc_386_parse_blif_2321 n120 n190 n191 VDD VDD VSS VSS gf180mcu_fd_sc_mcu7t5v0__nor2_1
X_abc_2207_auto_blifparse_cc_386_parse_blif_2322 n100 n109 n191 n192 VDD VDD VSS VSS gf180mcu_fd_sc_mcu7t5v0__nand3_1
X_abc_2207_auto_blifparse_cc_386_parse_blif_2323 n152 n192 n193 VDD VDD VSS VSS gf180mcu_fd_sc_mcu7t5v0__nand2_1
X_abc_2207_auto_blifparse_cc_386_parse_blif_2324 n194 n59 n195 VDD VDD VSS VSS gf180mcu_fd_sc_mcu7t5v0__nor2_1
X_abc_2207_auto_blifparse_cc_386_parse_blif_2325 n65 n195 n196 VDD VDD VSS VSS gf180mcu_fd_sc_mcu7t5v0__nor2_1
X_abc_2207_auto_blifparse_cc_386_parse_blif_2326 n62 n197 n198 VDD VDD VSS VSS gf180mcu_fd_sc_mcu7t5v0__or2_1
X_abc_2207_auto_blifparse_cc_386_parse_blif_2327 n64 n197 n66 n199 n200 VDD VDD VSS VSS gf180mcu_fd_sc_mcu7t5v0__aoi22_1
X_abc_2207_auto_blifparse_cc_386_parse_blif_2328 n64 n199 n198 n200 n201 VDD VDD VSS VSS gf180mcu_fd_sc_mcu7t5v0__oai211_1
X_abc_2207_auto_blifparse_cc_386_parse_blif_2329 n194 n202 n203 VDD VDD VSS VSS gf180mcu_fd_sc_mcu7t5v0__and2_1
X_abc_2207_auto_blifparse_cc_386_parse_blif_2330 n204 n196 n203 n195 n113 n205 VDD VDD VSS VSS gf180mcu_fd_sc_mcu7t5v0__oai221_1
X_abc_2207_auto_blifparse_cc_386_parse_blif_2331 n62 n202 n201 n205 n206 VDD VDD VSS VSS gf180mcu_fd_sc_mcu7t5v0__aoi211_1
X_abc_2207_auto_blifparse_cc_386_parse_blif_2332 n207 n208 n209 VDD VDD VSS VSS gf180mcu_fd_sc_mcu7t5v0__nand2_1
X_abc_2207_auto_blifparse_cc_386_parse_blif_2333 n208 n49 n209 n210 VDD VDD VSS VSS gf180mcu_fd_sc_mcu7t5v0__oai21_1
X_abc_2207_auto_blifparse_cc_386_parse_blif_2334 n211 n212 n213 VDD VDD VSS VSS gf180mcu_fd_sc_mcu7t5v0__nand2_1
X_abc_2207_auto_blifparse_cc_386_parse_blif_2335 n212 n55 n213 n214 VDD VDD VSS VSS gf180mcu_fd_sc_mcu7t5v0__oai21_1
X_abc_2207_auto_blifparse_cc_386_parse_blif_2336 n215 n51 n216 VDD VDD VSS VSS gf180mcu_fd_sc_mcu7t5v0__nand2_1
X_abc_2207_auto_blifparse_cc_386_parse_blif_2337 n51 n53 n216 n217 VDD VDD VSS VSS gf180mcu_fd_sc_mcu7t5v0__oai21_1
X_abc_2207_auto_blifparse_cc_386_parse_blif_2338 n218 n219 n220 VDD VDD VSS VSS gf180mcu_fd_sc_mcu7t5v0__nand2_1
X_abc_2207_auto_blifparse_cc_386_parse_blif_2339 n220 n221 VDD VDD VSS VSS gf180mcu_fd_sc_mcu7t5v0__clkinv_1
X_abc_2207_auto_blifparse_cc_386_parse_blif_2340 n222 n219 n220 n223 VDD VDD VSS VSS gf180mcu_fd_sc_mcu7t5v0__oai21_1
X_abc_2207_auto_blifparse_cc_386_parse_blif_2341 n56 n57 n113 n224 VDD VDD VSS VSS gf180mcu_fd_sc_mcu7t5v0__aoi21_1
X_abc_2207_auto_blifparse_cc_386_parse_blif_2342 n222 n225 n226 VDD VDD VSS VSS gf180mcu_fd_sc_mcu7t5v0__nand2_1
X_abc_2207_auto_blifparse_cc_386_parse_blif_2343 n225 n207 n226 n227 VDD VDD VSS VSS gf180mcu_fd_sc_mcu7t5v0__oai21_1
X_abc_2207_auto_blifparse_cc_386_parse_blif_2344 n49 n228 n229 VDD VDD VSS VSS gf180mcu_fd_sc_mcu7t5v0__nand2_1
X_abc_2207_auto_blifparse_cc_386_parse_blif_2345 n228 n215 n229 n230 VDD VDD VSS VSS gf180mcu_fd_sc_mcu7t5v0__oai21_1
X_abc_2207_auto_blifparse_cc_386_parse_blif_2346 n53 n231 n232 VDD VDD VSS VSS gf180mcu_fd_sc_mcu7t5v0__nand2_1
X_abc_2207_auto_blifparse_cc_386_parse_blif_2347 n231 n211 n232 n233 VDD VDD VSS VSS gf180mcu_fd_sc_mcu7t5v0__oai21_1
X_abc_2207_auto_blifparse_cc_386_parse_blif_2348 n210 n217 n224 n230 n234 VDD VDD VSS VSS gf180mcu_fd_sc_mcu7t5v0__nand4_1
X_abc_2207_auto_blifparse_cc_386_parse_blif_2349 n214 n223 n227 n233 n235 VDD VDD VSS VSS gf180mcu_fd_sc_mcu7t5v0__nand4_1
X_abc_2207_auto_blifparse_cc_386_parse_blif_2350 n234 n235 n236 VDD VDD VSS VSS gf180mcu_fd_sc_mcu7t5v0__nor2_1
X_abc_2207_auto_blifparse_cc_386_parse_blif_2351 n55 n57 n237 VDD VDD VSS VSS gf180mcu_fd_sc_mcu7t5v0__nand2_1
X_abc_2207_auto_blifparse_cc_386_parse_blif_2352 n213 n220 n226 n232 n238 VDD VDD VSS VSS gf180mcu_fd_sc_mcu7t5v0__nor4_1
X_abc_2207_auto_blifparse_cc_386_parse_blif_2353 n209 n216 n229 n237 n239 VDD VDD VSS VSS gf180mcu_fd_sc_mcu7t5v0__nor4_1
X_abc_2207_auto_blifparse_cc_386_parse_blif_2354 n238 n239 n240 VDD VDD VSS VSS gf180mcu_fd_sc_mcu7t5v0__nand2_1
X_abc_2207_auto_blifparse_cc_386_parse_blif_2355 n236 n240 n206 n241 VDD VDD VSS VSS gf180mcu_fd_sc_mcu7t5v0__aoi21_1
X_abc_2207_auto_blifparse_cc_386_parse_blif_2356 uio_oe_0 n99 n242 VDD VDD VSS VSS gf180mcu_fd_sc_mcu7t5v0__and2_1
X_abc_2207_auto_blifparse_cc_386_parse_blif_2357 n241 n242 n107 n243 VDD VDD VSS VSS gf180mcu_fd_sc_mcu7t5v0__aoi21_1
X_abc_2207_auto_blifparse_cc_386_parse_blif_2358 n192 n243 n193 n244 VDD VDD VSS VSS gf180mcu_fd_sc_mcu7t5v0__oai21_1
X_abc_2207_auto_blifparse_cc_386_parse_blif_2359 n117 n138 n127 n124 n245 VDD VDD VSS VSS gf180mcu_fd_sc_mcu7t5v0__oai211_1
X_abc_2207_auto_blifparse_cc_386_parse_blif_2360 n150 n245 n246 VDD VDD VSS VSS gf180mcu_fd_sc_mcu7t5v0__nand2_1
X_abc_2207_auto_blifparse_cc_386_parse_blif_2361 n118 n245 n246 n247 VDD VDD VSS VSS gf180mcu_fd_sc_mcu7t5v0__oai21_1
X_abc_2207_auto_blifparse_cc_386_parse_blif_2362 n157 n128 n248 VDD VDD VSS VSS gf180mcu_fd_sc_mcu7t5v0__nor2_1
X_abc_2207_auto_blifparse_cc_386_parse_blif_2363 n245 n248 n148 n249 VDD VDD VSS VSS gf180mcu_fd_sc_mcu7t5v0__oai21_1
X_abc_2207_auto_blifparse_cc_386_parse_blif_2364 n161 n245 n248 n249 n250 VDD VDD VSS VSS gf180mcu_fd_sc_mcu7t5v0__oai31_1
X_abc_2207_auto_blifparse_cc_386_parse_blif_2365 n113 n137 n251 VDD VDD VSS VSS gf180mcu_fd_sc_mcu7t5v0__nand2_1
X_abc_2207_auto_blifparse_cc_386_parse_blif_2366 uio_oe_0 n123 n112 n252 VDD VDD VSS VSS gf180mcu_fd_sc_mcu7t5v0__nand3_1
X_abc_2207_auto_blifparse_cc_386_parse_blif_2367 n251 n252 n253 VDD VDD VSS VSS gf180mcu_fd_sc_mcu7t5v0__nand2_1
X_abc_2207_auto_blifparse_cc_386_parse_blif_2368 n99 n97 n254 VDD VDD VSS VSS gf180mcu_fd_sc_mcu7t5v0__nand2_1
X_abc_2207_auto_blifparse_cc_386_parse_blif_2369 n241 n254 uio_oe_0 n255 VDD VDD VSS VSS gf180mcu_fd_sc_mcu7t5v0__oai21_1
X_abc_2207_auto_blifparse_cc_386_parse_blif_2370 n231 n212 n256 VDD VDD VSS VSS gf180mcu_fd_sc_mcu7t5v0__nand2_1
X_abc_2207_auto_blifparse_cc_386_parse_blif_2371 n231 n212 n257 VDD VDD VSS VSS gf180mcu_fd_sc_mcu7t5v0__nor2_1
X_abc_2207_auto_blifparse_cc_386_parse_blif_2372 n231 n212 n57 n258 VDD VDD VSS VSS gf180mcu_fd_sc_mcu7t5v0__xor3_1
X_abc_2207_auto_blifparse_cc_386_parse_blif_2373 n211 n258 n259 VDD VDD VSS VSS gf180mcu_fd_sc_mcu7t5v0__nor2_1
X_abc_2207_auto_blifparse_cc_386_parse_blif_2374 n211 n258 n260 VDD VDD VSS VSS gf180mcu_fd_sc_mcu7t5v0__nand2_1
X_abc_2207_auto_blifparse_cc_386_parse_blif_2375 n53 n211 n258 n261 VDD VDD VSS VSS gf180mcu_fd_sc_mcu7t5v0__xor3_1
X_abc_2207_auto_blifparse_cc_386_parse_blif_2376 n261 n262 VDD VDD VSS VSS gf180mcu_fd_sc_mcu7t5v0__clkinv_1
X_abc_2207_auto_blifparse_cc_386_parse_blif_2377 n208 n228 n263 VDD VDD VSS VSS gf180mcu_fd_sc_mcu7t5v0__nand2_1
X_abc_2207_auto_blifparse_cc_386_parse_blif_2378 n208 n228 n264 VDD VDD VSS VSS gf180mcu_fd_sc_mcu7t5v0__nor2_1
X_abc_2207_auto_blifparse_cc_386_parse_blif_2379 n208 n228 n51 n265 VDD VDD VSS VSS gf180mcu_fd_sc_mcu7t5v0__xor3_1
X_abc_2207_auto_blifparse_cc_386_parse_blif_2380 n218 n219 n266 VDD VDD VSS VSS gf180mcu_fd_sc_mcu7t5v0__or2_1
X_abc_2207_auto_blifparse_cc_386_parse_blif_2381 n218 n219 n225 n267 VDD VDD VSS VSS gf180mcu_fd_sc_mcu7t5v0__xor3_1
X_abc_2207_auto_blifparse_cc_386_parse_blif_2382 n55 n267 n268 VDD VDD VSS VSS gf180mcu_fd_sc_mcu7t5v0__and2_1
X_abc_2207_auto_blifparse_cc_386_parse_blif_2383 n55 n267 n269 VDD VDD VSS VSS gf180mcu_fd_sc_mcu7t5v0__or2_1
X_abc_2207_auto_blifparse_cc_386_parse_blif_2384 n55 n265 n267 n270 VDD VDD VSS VSS gf180mcu_fd_sc_mcu7t5v0__xor3_1
X_abc_2207_auto_blifparse_cc_386_parse_blif_2385 n215 n270 n271 VDD VDD VSS VSS gf180mcu_fd_sc_mcu7t5v0__nand2_1
X_abc_2207_auto_blifparse_cc_386_parse_blif_2386 n215 n270 n272 VDD VDD VSS VSS gf180mcu_fd_sc_mcu7t5v0__nor2_1
X_abc_2207_auto_blifparse_cc_386_parse_blif_2387 n215 n270 n273 VDD VDD VSS VSS gf180mcu_fd_sc_mcu7t5v0__or2_1
X_abc_2207_auto_blifparse_cc_386_parse_blif_2388 n261 n271 n273 n274 VDD VDD VSS VSS gf180mcu_fd_sc_mcu7t5v0__nand3_1
X_abc_2207_auto_blifparse_cc_386_parse_blif_2389 n215 n261 n270 n275 VDD VDD VSS VSS gf180mcu_fd_sc_mcu7t5v0__xor3_1
X_abc_2207_auto_blifparse_cc_386_parse_blif_2390 n207 n275 n276 VDD VDD VSS VSS gf180mcu_fd_sc_mcu7t5v0__nor2_1
X_abc_2207_auto_blifparse_cc_386_parse_blif_2391 n207 n275 n277 VDD VDD VSS VSS gf180mcu_fd_sc_mcu7t5v0__nand2_1
X_abc_2207_auto_blifparse_cc_386_parse_blif_2392 n207 n275 n278 VDD VDD VSS VSS gf180mcu_fd_sc_mcu7t5v0__xor2_1
X_abc_2207_auto_blifparse_cc_386_parse_blif_2393 n49 n278 n279 VDD VDD VSS VSS gf180mcu_fd_sc_mcu7t5v0__nand2_1
X_abc_2207_auto_blifparse_cc_386_parse_blif_2394 n49 n278 n280 VDD VDD VSS VSS gf180mcu_fd_sc_mcu7t5v0__xor2_1
X_abc_2207_auto_blifparse_cc_386_parse_blif_2395 n222 n280 n281 VDD VDD VSS VSS gf180mcu_fd_sc_mcu7t5v0__and2_1
X_abc_2207_auto_blifparse_cc_386_parse_blif_2396 n222 n280 n282 VDD VDD VSS VSS gf180mcu_fd_sc_mcu7t5v0__xor2_1
X_abc_2207_auto_blifparse_cc_386_parse_blif_2397 n194 n202 n283 VDD VDD VSS VSS gf180mcu_fd_sc_mcu7t5v0__nor2_1
X_abc_2207_auto_blifparse_cc_386_parse_blif_2398 n197 n203 n283 n284 VDD VDD VSS VSS gf180mcu_fd_sc_mcu7t5v0__nor3_1
X_abc_2207_auto_blifparse_cc_386_parse_blif_2399 n194 n202 n197 n285 VDD VDD VSS VSS gf180mcu_fd_sc_mcu7t5v0__xnor3_1
X_abc_2207_auto_blifparse_cc_386_parse_blif_2400 n60 n285 n286 VDD VDD VSS VSS gf180mcu_fd_sc_mcu7t5v0__nor2_1
X_abc_2207_auto_blifparse_cc_386_parse_blif_2401 n60 n285 n287 VDD VDD VSS VSS gf180mcu_fd_sc_mcu7t5v0__nand2_1
X_abc_2207_auto_blifparse_cc_386_parse_blif_2402 n59 n199 n285 n288 VDD VDD VSS VSS gf180mcu_fd_sc_mcu7t5v0__xor3_1
X_abc_2207_auto_blifparse_cc_386_parse_blif_2403 n66 n288 n289 VDD VDD VSS VSS gf180mcu_fd_sc_mcu7t5v0__nor2_1
X_abc_2207_auto_blifparse_cc_386_parse_blif_2404 n66 n288 n290 VDD VDD VSS VSS gf180mcu_fd_sc_mcu7t5v0__nand2_1
X_abc_2207_auto_blifparse_cc_386_parse_blif_2405 n65 n204 n288 n291 VDD VDD VSS VSS gf180mcu_fd_sc_mcu7t5v0__xor3_1
X_abc_2207_auto_blifparse_cc_386_parse_blif_2406 n64 n291 n292 VDD VDD VSS VSS gf180mcu_fd_sc_mcu7t5v0__and2_1
X_abc_2207_auto_blifparse_cc_386_parse_blif_2407 n63 n291 n293 VDD VDD VSS VSS gf180mcu_fd_sc_mcu7t5v0__xor2_1
X_abc_2207_auto_blifparse_cc_386_parse_blif_2408 n61 n293 n294 VDD VDD VSS VSS gf180mcu_fd_sc_mcu7t5v0__nor2_1
X_abc_2207_auto_blifparse_cc_386_parse_blif_2409 n62 n293 n295 VDD VDD VSS VSS gf180mcu_fd_sc_mcu7t5v0__xor2_1
X_abc_2207_auto_blifparse_cc_386_parse_blif_2410 uio_oe_0 n255 n296 VDD VDD VSS VSS gf180mcu_fd_sc_mcu7t5v0__nand2_1
X_abc_2207_auto_blifparse_cc_386_parse_blif_2411 n113 n295 n296 n297 VDD VDD VSS VSS gf180mcu_fd_sc_mcu7t5v0__aoi21_1
X_abc_2207_auto_blifparse_cc_386_parse_blif_2412 n113 n282 n297 n298 VDD VDD VSS VSS gf180mcu_fd_sc_mcu7t5v0__oai21_1
X_abc_2207_auto_blifparse_cc_386_parse_blif_2413 n79 n255 n298 n299 VDD VDD VSS VSS gf180mcu_fd_sc_mcu7t5v0__oai21_1
X_abc_2207_auto_blifparse_cc_386_parse_blif_2414 n50 n276 n277 n300 VDD VDD VSS VSS gf180mcu_fd_sc_mcu7t5v0__oai21_1
X_abc_2207_auto_blifparse_cc_386_parse_blif_2415 n54 n259 n260 n301 VDD VDD VSS VSS gf180mcu_fd_sc_mcu7t5v0__oai21_1
X_abc_2207_auto_blifparse_cc_386_parse_blif_2416 n262 n272 n271 n302 VDD VDD VSS VSS gf180mcu_fd_sc_mcu7t5v0__oai21_1
X_abc_2207_auto_blifparse_cc_386_parse_blif_2417 n58 n257 n256 n303 VDD VDD VSS VSS gf180mcu_fd_sc_mcu7t5v0__oai21_1
X_abc_2207_auto_blifparse_cc_386_parse_blif_2418 n52 n264 n263 n304 VDD VDD VSS VSS gf180mcu_fd_sc_mcu7t5v0__oai21_1
X_abc_2207_auto_blifparse_cc_386_parse_blif_2419 n303 n304 n305 VDD VDD VSS VSS gf180mcu_fd_sc_mcu7t5v0__nand2_1
X_abc_2207_auto_blifparse_cc_386_parse_blif_2420 n303 n304 n306 VDD VDD VSS VSS gf180mcu_fd_sc_mcu7t5v0__xnor2_1
X_abc_2207_auto_blifparse_cc_386_parse_blif_2421 n265 n269 n268 n307 VDD VDD VSS VSS gf180mcu_fd_sc_mcu7t5v0__aoi21_1
X_abc_2207_auto_blifparse_cc_386_parse_blif_2422 n225 n266 n221 n308 VDD VDD VSS VSS gf180mcu_fd_sc_mcu7t5v0__aoi21_1
X_abc_2207_auto_blifparse_cc_386_parse_blif_2423 n307 n308 n309 VDD VDD VSS VSS gf180mcu_fd_sc_mcu7t5v0__or2_1
X_abc_2207_auto_blifparse_cc_386_parse_blif_2424 n307 n308 n310 VDD VDD VSS VSS gf180mcu_fd_sc_mcu7t5v0__xnor2_1
X_abc_2207_auto_blifparse_cc_386_parse_blif_2425 n306 n310 n311 VDD VDD VSS VSS gf180mcu_fd_sc_mcu7t5v0__or2_1
X_abc_2207_auto_blifparse_cc_386_parse_blif_2426 n306 n307 n308 n312 VDD VDD VSS VSS gf180mcu_fd_sc_mcu7t5v0__xor3_1
X_abc_2207_auto_blifparse_cc_386_parse_blif_2427 n271 n274 n312 n313 VDD VDD VSS VSS gf180mcu_fd_sc_mcu7t5v0__aoi21_1
X_abc_2207_auto_blifparse_cc_386_parse_blif_2428 n302 n312 n314 VDD VDD VSS VSS gf180mcu_fd_sc_mcu7t5v0__xnor2_1
X_abc_2207_auto_blifparse_cc_386_parse_blif_2429 n301 n314 n315 VDD VDD VSS VSS gf180mcu_fd_sc_mcu7t5v0__and2_1
X_abc_2207_auto_blifparse_cc_386_parse_blif_2430 n301 n302 n312 n316 VDD VDD VSS VSS gf180mcu_fd_sc_mcu7t5v0__xor3_1
X_abc_2207_auto_blifparse_cc_386_parse_blif_2431 n277 n279 n316 n317 VDD VDD VSS VSS gf180mcu_fd_sc_mcu7t5v0__aoi21_1
X_abc_2207_auto_blifparse_cc_386_parse_blif_2432 n300 n316 n318 VDD VDD VSS VSS gf180mcu_fd_sc_mcu7t5v0__xnor2_1
X_abc_2207_auto_blifparse_cc_386_parse_blif_2433 n281 n318 n319 VDD VDD VSS VSS gf180mcu_fd_sc_mcu7t5v0__xor2_1
X_abc_2207_auto_blifparse_cc_386_parse_blif_2434 n204 n289 n290 n320 VDD VDD VSS VSS gf180mcu_fd_sc_mcu7t5v0__oai21_1
X_abc_2207_auto_blifparse_cc_386_parse_blif_2435 n199 n286 n287 n321 VDD VDD VSS VSS gf180mcu_fd_sc_mcu7t5v0__oai21_1
X_abc_2207_auto_blifparse_cc_386_parse_blif_2436 n283 n284 n322 VDD VDD VSS VSS gf180mcu_fd_sc_mcu7t5v0__nor2_1
X_abc_2207_auto_blifparse_cc_386_parse_blif_2437 n283 n284 n321 n323 VDD VDD VSS VSS gf180mcu_fd_sc_mcu7t5v0__oai21_1
X_abc_2207_auto_blifparse_cc_386_parse_blif_2438 n321 n322 n324 VDD VDD VSS VSS gf180mcu_fd_sc_mcu7t5v0__xnor2_1
X_abc_2207_auto_blifparse_cc_386_parse_blif_2439 n320 n324 n325 VDD VDD VSS VSS gf180mcu_fd_sc_mcu7t5v0__nand2_1
X_abc_2207_auto_blifparse_cc_386_parse_blif_2440 n320 n324 n326 VDD VDD VSS VSS gf180mcu_fd_sc_mcu7t5v0__xor2_1
X_abc_2207_auto_blifparse_cc_386_parse_blif_2441 n292 n294 n326 n327 VDD VDD VSS VSS gf180mcu_fd_sc_mcu7t5v0__or3_1
X_abc_2207_auto_blifparse_cc_386_parse_blif_2442 n292 n294 n326 n328 VDD VDD VSS VSS gf180mcu_fd_sc_mcu7t5v0__oai21_1
X_abc_2207_auto_blifparse_cc_386_parse_blif_2443 n327 n328 n329 VDD VDD VSS VSS gf180mcu_fd_sc_mcu7t5v0__nand2_1
X_abc_2207_auto_blifparse_cc_386_parse_blif_2444 n113 n329 n296 n330 VDD VDD VSS VSS gf180mcu_fd_sc_mcu7t5v0__aoi21_1
X_abc_2207_auto_blifparse_cc_386_parse_blif_2445 n113 n319 n330 n331 VDD VDD VSS VSS gf180mcu_fd_sc_mcu7t5v0__oai21_1
X_abc_2207_auto_blifparse_cc_386_parse_blif_2446 n81 n255 n331 n332 VDD VDD VSS VSS gf180mcu_fd_sc_mcu7t5v0__oai21_1
X_abc_2207_auto_blifparse_cc_386_parse_blif_2447 n323 n325 n328 n333 VDD VDD VSS VSS gf180mcu_fd_sc_mcu7t5v0__nand3_1
X_abc_2207_auto_blifparse_cc_386_parse_blif_2448 n323 n328 n113 n334 VDD VDD VSS VSS gf180mcu_fd_sc_mcu7t5v0__oai21_1
X_abc_2207_auto_blifparse_cc_386_parse_blif_2449 n334 n335 VDD VDD VSS VSS gf180mcu_fd_sc_mcu7t5v0__clkinv_1
X_abc_2207_auto_blifparse_cc_386_parse_blif_2450 n281 n318 n317 n336 VDD VDD VSS VSS gf180mcu_fd_sc_mcu7t5v0__aoi21_1
X_abc_2207_auto_blifparse_cc_386_parse_blif_2451 n301 n314 n313 n337 VDD VDD VSS VSS gf180mcu_fd_sc_mcu7t5v0__aoi21_1
X_abc_2207_auto_blifparse_cc_386_parse_blif_2452 n309 n311 n338 VDD VDD VSS VSS gf180mcu_fd_sc_mcu7t5v0__nand2_1
X_abc_2207_auto_blifparse_cc_386_parse_blif_2453 n305 n309 n339 VDD VDD VSS VSS gf180mcu_fd_sc_mcu7t5v0__or2_1
X_abc_2207_auto_blifparse_cc_386_parse_blif_2454 n305 n309 n311 n340 VDD VDD VSS VSS gf180mcu_fd_sc_mcu7t5v0__nand3_1
X_abc_2207_auto_blifparse_cc_386_parse_blif_2455 n313 n315 n339 n340 n341 VDD VDD VSS VSS gf180mcu_fd_sc_mcu7t5v0__oai211_1
X_abc_2207_auto_blifparse_cc_386_parse_blif_2456 n305 n337 n338 n342 VDD VDD VSS VSS gf180mcu_fd_sc_mcu7t5v0__xnor3_1
X_abc_2207_auto_blifparse_cc_386_parse_blif_2457 n336 n342 n343 VDD VDD VSS VSS gf180mcu_fd_sc_mcu7t5v0__or2_1
X_abc_2207_auto_blifparse_cc_386_parse_blif_2458 n336 n342 n113 n344 VDD VDD VSS VSS gf180mcu_fd_sc_mcu7t5v0__aoi21_1
X_abc_2207_auto_blifparse_cc_386_parse_blif_2459 n333 n335 n343 n344 n345 VDD VDD VSS VSS gf180mcu_fd_sc_mcu7t5v0__aoi22_1
X_abc_2207_auto_blifparse_cc_386_parse_blif_2460 n83 n255 n296 n345 n346 VDD VDD VSS VSS gf180mcu_fd_sc_mcu7t5v0__oai22_1
X_abc_2207_auto_blifparse_cc_386_parse_blif_2461 n336 n342 n341 n339 n347 VDD VDD VSS VSS gf180mcu_fd_sc_mcu7t5v0__oai211_1
X_abc_2207_auto_blifparse_cc_386_parse_blif_2462 n240 n347 n113 n348 VDD VDD VSS VSS gf180mcu_fd_sc_mcu7t5v0__aoi21_1
X_abc_2207_auto_blifparse_cc_386_parse_blif_2463 n296 n335 n348 n255 n85 n349 VDD VDD VSS VSS gf180mcu_fd_sc_mcu7t5v0__oai32_1
X_abc_2207_auto_blifparse_cc_386_parse_blif_2464 n113 n71 n296 n255 n87 n350 VDD VDD VSS VSS gf180mcu_fd_sc_mcu7t5v0__oai32_1
X_abc_2207_auto_blifparse_cc_386_parse_blif_2465 n113 n73 n296 n255 n89 n351 VDD VDD VSS VSS gf180mcu_fd_sc_mcu7t5v0__oai32_1
X_abc_2207_auto_blifparse_cc_386_parse_blif_2466 n113 n75 n296 n255 n91 n352 VDD VDD VSS VSS gf180mcu_fd_sc_mcu7t5v0__oai32_1
X_abc_2207_auto_blifparse_cc_386_parse_blif_2467 n113 n77 n296 n255 n93 n353 VDD VDD VSS VSS gf180mcu_fd_sc_mcu7t5v0__oai32_1
X_abc_2207_auto_blifparse_cc_386_parse_blif_2468 n67 n354 n69 n355 VDD VDD VSS VSS gf180mcu_fd_sc_mcu7t5v0__oai21_1
X_abc_2207_auto_blifparse_cc_386_parse_blif_2469 n155 n164 n356 VDD VDD VSS VSS gf180mcu_fd_sc_mcu7t5v0__nand2_1
X_abc_2207_auto_blifparse_cc_386_parse_blif_2470 n190 n133 n356 n357 VDD VDD VSS VSS gf180mcu_fd_sc_mcu7t5v0__mux2_1
X_abc_2207_auto_blifparse_cc_386_parse_blif_2471 n68 n358 n359 VDD VDD VSS VSS gf180mcu_fd_sc_mcu7t5v0__nand2_1
X_abc_2207_auto_blifparse_cc_386_parse_blif_2472 n68 n358 n360 VDD VDD VSS VSS gf180mcu_fd_sc_mcu7t5v0__xor2_1
X_abc_2207_auto_blifparse_cc_386_parse_blif_2473 n68 n361 n358 n362 VDD VDD VSS VSS gf180mcu_fd_sc_mcu7t5v0__nand3_1
X_abc_2207_auto_blifparse_cc_386_parse_blif_2474 n361 n359 n363 VDD VDD VSS VSS gf180mcu_fd_sc_mcu7t5v0__xnor2_1
X_abc_2207_auto_blifparse_cc_386_parse_blif_2475 n68 n361 n358 n364 n365 VDD VDD VSS VSS gf180mcu_fd_sc_mcu7t5v0__nand4_1
X_abc_2207_auto_blifparse_cc_386_parse_blif_2476 n364 n362 n366 VDD VDD VSS VSS gf180mcu_fd_sc_mcu7t5v0__xnor2_1
X_abc_2207_auto_blifparse_cc_386_parse_blif_2477 n367 n365 n368 VDD VDD VSS VSS gf180mcu_fd_sc_mcu7t5v0__xnor2_1
X_auto_ff_cc_266_slice_1125 ui_in_6 n132 clk n369 VDD VDD VSS VSS gf180mcu_fd_sc_mcu7t5v0__dffrnq_1
X_auto_ff_cc_266_slice_1126 n369 n132 clk n112 VDD VDD VSS VSS gf180mcu_fd_sc_mcu7t5v0__dffrnq_1
X_auto_ff_cc_266_slice_1127 n145 n132 clk n146 VDD VDD VSS VSS gf180mcu_fd_sc_mcu7t5v0__dffrnq_1
X_auto_ff_cc_266_slice_1128 n147 n132 clk n47 VDD VDD VSS VSS gf180mcu_fd_sc_mcu7t5v0__dffrnq_1
X_auto_ff_cc_266_slice_1129 n139 n132 clk n140 VDD VDD VSS VSS gf180mcu_fd_sc_mcu7t5v0__dffrnq_1
X_auto_ff_cc_266_slice_1130 n141 n132 clk n119 VDD VDD VSS VSS gf180mcu_fd_sc_mcu7t5v0__dffrnq_1
X_auto_ff_cc_266_slice_1131 n160 n132 clk n157 VDD VDD VSS VSS gf180mcu_fd_sc_mcu7t5v0__dffrnq_1
X_auto_ff_cc_266_slice_1132 n168 n132 clk n41 VDD VDD VSS VSS gf180mcu_fd_sc_mcu7t5v0__dffrnq_1
X_auto_ff_cc_266_slice_1133 n172 n132 clk n94 VDD VDD VSS VSS gf180mcu_fd_sc_mcu7t5v0__dffrnq_1
X_auto_ff_cc_266_slice_1134 n174 n132 clk n96 VDD VDD VSS VSS gf180mcu_fd_sc_mcu7t5v0__dffrnq_1
X_auto_ff_cc_266_slice_1135 n176 n132 clk n43 VDD VDD VSS VSS gf180mcu_fd_sc_mcu7t5v0__dffrnq_1
X_auto_ff_cc_266_slice_1136 n181 n132 clk n102 VDD VDD VSS VSS gf180mcu_fd_sc_mcu7t5v0__dffrnq_1
X_auto_ff_cc_266_slice_1137 n185 n132 clk n101 VDD VDD VSS VSS gf180mcu_fd_sc_mcu7t5v0__dffrnq_1
X_auto_ff_cc_266_slice_1138 n187 n132 clk n104 VDD VDD VSS VSS gf180mcu_fd_sc_mcu7t5v0__dffrnq_1
X_auto_ff_cc_266_slice_1139 n189 n132 clk n45 VDD VDD VSS VSS gf180mcu_fd_sc_mcu7t5v0__dffrnq_1
X_auto_ff_cc_266_slice_1140 n244 n132 clk n152 VDD VDD VSS VSS gf180mcu_fd_sc_mcu7t5v0__dffrnq_1
X_auto_ff_cc_266_slice_1154 n247 n132 clk n150 VDD VDD VSS VSS gf180mcu_fd_sc_mcu7t5v0__dffrnq_1
X_auto_ff_cc_266_slice_1155 n250 n132 clk n148 VDD VDD VSS VSS gf180mcu_fd_sc_mcu7t5v0__dffrnq_1
X_auto_ff_cc_266_slice_1156 n253 n132 clk n113 VDD VDD VSS VSS gf180mcu_fd_sc_mcu7t5v0__dffrnq_1
X_auto_ff_cc_266_slice_1157 n299 n132 clk n78 VDD VDD VSS VSS gf180mcu_fd_sc_mcu7t5v0__dffrnq_1
X_auto_ff_cc_266_slice_1158 n332 n132 clk n80 VDD VDD VSS VSS gf180mcu_fd_sc_mcu7t5v0__dffrnq_1
X_auto_ff_cc_266_slice_1159 n346 n132 clk n82 VDD VDD VSS VSS gf180mcu_fd_sc_mcu7t5v0__dffrnq_1
X_auto_ff_cc_266_slice_1160 n349 n132 clk n84 VDD VDD VSS VSS gf180mcu_fd_sc_mcu7t5v0__dffrnq_1
X_auto_ff_cc_266_slice_1161 n350 n132 clk n86 VDD VDD VSS VSS gf180mcu_fd_sc_mcu7t5v0__dffrnq_1
X_auto_ff_cc_266_slice_1162 n351 n132 clk n88 VDD VDD VSS VSS gf180mcu_fd_sc_mcu7t5v0__dffrnq_1
X_auto_ff_cc_266_slice_1163 n352 n132 clk n90 VDD VDD VSS VSS gf180mcu_fd_sc_mcu7t5v0__dffrnq_1
X_auto_ff_cc_266_slice_1164 n353 n132 clk n92 VDD VDD VSS VSS gf180mcu_fd_sc_mcu7t5v0__dffrnq_1
X_auto_ff_cc_266_slice_1317 n355 n134 clk n68 VDD VDD VSS VSS gf180mcu_fd_sc_mcu7t5v0__dffrnq_1
X_auto_ff_cc_266_slice_691 n357 n132 clk n133 VDD VDD VSS VSS gf180mcu_fd_sc_mcu7t5v0__dffrnq_1
X_auto_ff_cc_266_slice_692 n360 n134 clk n358 VDD VDD VSS VSS gf180mcu_fd_sc_mcu7t5v0__dffnrnq_1
X_auto_ff_cc_266_slice_693 n363 n134 clk n361 VDD VDD VSS VSS gf180mcu_fd_sc_mcu7t5v0__dffnrnq_1
X_auto_ff_cc_266_slice_694 n366 n134 clk n364 VDD VDD VSS VSS gf180mcu_fd_sc_mcu7t5v0__dffnrnq_1
X_auto_ff_cc_266_slice_695 n368 n134 clk n367 VDD VDD VSS VSS gf180mcu_fd_sc_mcu7t5v0__dffnrnq_1
X_auto_ff_cc_266_slice_696 ui_in_0 n132 clk n354 VDD VDD VSS VSS gf180mcu_fd_sc_mcu7t5v0__dffrnq_1
X_auto_ff_cc_266_slice_697 VDD rst_n clk n370 VDD VDD VSS VSS gf180mcu_fd_sc_mcu7t5v0__dffrnq_1
X_auto_ff_cc_266_slice_698 n370 rst_n clk n132 VDD VDD VSS VSS gf180mcu_fd_sc_mcu7t5v0__dffrnq_1
X_auto_ff_cc_266_slice_915 n126 n132 clk n123 VDD VDD VSS VSS gf180mcu_fd_sc_mcu7t5v0__dffsnq_1
X_auto_ff_cc_266_slice_916 n131 n132 clk n106 VDD VDD VSS VSS gf180mcu_fd_sc_mcu7t5v0__dffrnq_1
X_auto_ff_cc_266_slice_917 n129 n132 clk n117 VDD VDD VSS VSS gf180mcu_fd_sc_mcu7t5v0__dffrnq_1
X_auto_ff_cc_266_slice_918 n111 n132 clk n99 VDD VDD VSS VSS gf180mcu_fd_sc_mcu7t5v0__dffrnq_1
Xboundary_demo n371 n143 VDD VDD VSS VSS gf180mcu_fd_sc_mcu7t5v0__buf_4
Xboundary_demo_launch n135 n372 VDD VDD VSS VSS gf180mcu_fd_sc_mcu7t5v0__buf_4
Xboundary_start n68 n115 VDD VDD VSS VSS gf180mcu_fd_sc_mcu7t5v0__buf_4
Xboundary_stop n373 n142 VDD VDD VSS VSS gf180mcu_fd_sc_mcu7t5v0__buf_4
Xdemo_vernier n372 n371 n59 n194 n202 n61 n197 n63 n199 n65 n204 VDD VSS tdc_vernier
Xstimulus n372 ua_0 n371 VDD VSS tdc_vcd
Xstop_endpoint ui_in_1 n136 n134 clk n358 n361 n364 n367 n374 n373 n70 n72 n74 n76 n218 n219 n222 n225 n207 n208 n49 n228 n215 n51 n53 n231 n211 n212 n55 n57 VDD VSS tdc_frontend
.ends tt_um_daiyan_tdc
