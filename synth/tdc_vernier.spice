* Generated by scripts/synthesize.py; do not edit.
.subckt tdc_vernier slow_in fast_in fine_0 fine_1 fine_2 fine_3 fine_4 fine_5 fine_6 fine_7 fine_8 VDD VSS
Xstages_0__compare n14 n13 fine_0 VDD VDD VSS VSS gf180mcu_fd_sc_mcu7t5v0__dffq_1
Xstages_0__fast_cell fast_in n14 VDD VDD VSS VSS gf180mcu_fd_sc_mcu7t5v0__dlya_1
Xstages_0__slow_cell slow_in n13 VDD VDD VSS VSS gf180mcu_fd_sc_mcu7t5v0__dlya_4
Xstages_1__compare n16 n15 fine_1 VDD VDD VSS VSS gf180mcu_fd_sc_mcu7t5v0__dffq_1
Xstages_1__fast_cell n14 n16 VDD VDD VSS VSS gf180mcu_fd_sc_mcu7t5v0__dlya_1
Xstages_1__slow_cell n13 n15 VDD VDD VSS VSS gf180mcu_fd_sc_mcu7t5v0__dlya_4
Xstages_2__compare n18 n17 fine_2 VDD VDD VSS VSS gf180mcu_fd_sc_mcu7t5v0__dffq_1
Xstages_2__fast_cell n16 n18 VDD VDD VSS VSS gf180mcu_fd_sc_mcu7t5v0__dlya_1
Xstages_2__slow_cell n15 n17 VDD VDD VSS VSS gf180mcu_fd_sc_mcu7t5v0__dlya_4
Xstages_3__compare n20 n19 fine_3 VDD VDD VSS VSS gf180mcu_fd_sc_mcu7t5v0__dffq_1
Xstages_3__fast_cell n18 n20 VDD VDD VSS VSS gf180mcu_fd_sc_mcu7t5v0__dlya_1
Xstages_3__slow_cell n17 n19 VDD VDD VSS VSS gf180mcu_fd_sc_mcu7t5v0__dlya_4
Xstages_4__compare n22 n21 fine_4 VDD VDD VSS VSS gf180mcu_fd_sc_mcu7t5v0__dffq_1
Xstages_4__fast_cell n20 n22 VDD VDD VSS VSS gf180mcu_fd_sc_mcu7t5v0__dlya_1
Xstages_4__slow_cell n19 n21 VDD VDD VSS VSS gf180mcu_fd_sc_mcu7t5v0__dlya_4
Xstages_5__compare n24 n23 fine_5 VDD VDD VSS VSS gf180mcu_fd_sc_mcu7t5v0__dffq_1
Xstages_5__fast_cell n22 n24 VDD VDD VSS VSS gf180mcu_fd_sc_mcu7t5v0__dlya_1
Xstages_5__slow_cell n21 n23 VDD VDD VSS VSS gf180mcu_fd_sc_mcu7t5v0__dlya_4
Xstages_6__compare n26 n25 fine_6 VDD VDD VSS VSS gf180mcu_fd_sc_mcu7t5v0__dffq_1
Xstages_6__fast_cell n24 n26 VDD VDD VSS VSS gf180mcu_fd_sc_mcu7t5v0__dlya_1
Xstages_6__slow_cell n23 n25 VDD VDD VSS VSS gf180mcu_fd_sc_mcu7t5v0__dlya_4
Xstages_7__compare n28 n27 fine_7 VDD VDD VSS VSS gf180mcu_fd_sc_mcu7t5v0__dffq_1
Xstages_7__fast_cell n26 n28 VDD VDD VSS VSS gf180mcu_fd_sc_mcu7t5v0__dlya_1
Xstages_7__slow_cell n25 n27 VDD VDD VSS VSS gf180mcu_fd_sc_mcu7t5v0__dlya_4
Xstages_8__compare n30 n29 fine_8 VDD VDD VSS VSS gf180mcu_fd_sc_mcu7t5v0__dffq_1
Xstages_8__fast_cell n28 n30 VDD VDD VSS VSS gf180mcu_fd_sc_mcu7t5v0__dlya_1
Xstages_8__slow_cell n27 n29 VDD VDD VSS VSS gf180mcu_fd_sc_mcu7t5v0__dlya_4
.ends tdc_vernier
